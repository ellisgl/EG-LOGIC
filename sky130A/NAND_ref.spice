* NAND reference (sky130A)
.subckt NAND A B Y VDD VSS
X1 Y A VDD VDD sky130_fd_pr__pfet_01v8 w=1 l=0.15
X2 VDD B Y VDD sky130_fd_pr__pfet_01v8 w=1 l=0.15
X3 Y A n0_1 VSS sky130_fd_pr__nfet_01v8 w=0.65 l=0.15
X4 n0_1 B VSS VSS sky130_fd_pr__nfet_01v8 w=0.65 l=0.15
.ends
