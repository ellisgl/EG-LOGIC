* ALU181 test (gf180mcuD)
.include /home/ellis/pdk/gf180mcuD/libs.tech/ngspice/design.ngspice
.lib /home/ellis/pdk/gf180mcuD/libs.tech/ngspice/sm141064.ngspice typical

* NGSPICE file created from ALU181.ext - technology: gf180mcuD

.subckt AND A B Y VDD VSS a_323_n286# a_469_n286#
M0 VDD A a_323_n286# VDD pfet_03v3 ad=0.53p pd=2.53u as=0.9p ps=4.9u w=2u l=0.28u
M1 a_469_n286# A a_323_n286# VSS nfet_03v3 ad=0.265p pd=1.53u as=0.45p ps=2.9u w=1u l=0.28u
M2 Y a_323_n286# VSS VSS nfet_03v3 ad=0.625p pd=3.25u as=0.625p ps=3.25u w=1u l=0.28u
M3 VSS B a_469_n286# VSS nfet_03v3 ad=0.45p pd=2.9u as=0.265p ps=1.53u w=1u l=0.28u
M4 Y a_323_n286# VDD VDD pfet_03v3 ad=1.25p pd=5.25u as=1.25p ps=5.25u w=2u l=0.28u
M5 a_323_n286# B VDD VDD pfet_03v3 ad=0.9p pd=4.9u as=0.53p ps=2.53u w=2u l=0.28u
C0 a_323_n286# a_469_n286# 0.01435f
C1 a_323_n286# VDD 1.15177f
C2 a_323_n286# A 0.06277f
C3 a_323_n286# B 0.07031f
C4 a_323_n286# Y 0.12848f
C5 a_469_n286# VDD 0.00121f
C6 a_469_n286# Y 0
C7 VDD A 0.58621f
C8 VDD B 0.12259f
C9 VDD Y 0.55505f
C10 A B 0.05053f
C11 A Y 0
C12 B Y 0
C13 Y VSS 0.64505f
C14 B VSS 1.16274f
C15 A VSS 0.42529f
C16 VDD VSS 6.00341f
C17 a_469_n286# VSS 0.01616f
C18 a_323_n286# VSS 0.44193f
.ends

.subckt NAND A B Y VDD VSS a_512_n286#
M0 a_512_n286# A Y VSS nfet_03v3 ad=0.265p pd=1.53u as=0.45p ps=2.9u w=1u l=0.28u
M1 Y B VDD VDD pfet_03v3 ad=0.9p pd=4.9u as=0.53p ps=2.53u w=2u l=0.28u
M2 VSS B a_512_n286# VSS nfet_03v3 ad=0.45p pd=2.9u as=0.265p ps=1.53u w=1u l=0.28u
M3 VDD A Y VDD pfet_03v3 ad=0.53p pd=2.53u as=0.9p ps=4.9u w=2u l=0.28u
C0 a_512_n286# VDD 0.00121f
C1 a_512_n286# Y 0.01435f
C2 VDD A 0.61554f
C3 VDD B 0.12644f
C4 VDD Y 1.2128f
C5 A B 0.05095f
C6 A Y 0.06299f
C7 B Y 0.06123f
C8 Y VSS 1.65258f
C9 B VSS 1.19862f
C10 A VSS 0.4271f
C11 VDD VSS 6.05143f
C12 a_512_n286# VSS 0.01607f
.ends

.subckt NOT A Y VDD VSS
M0 Y A VDD VDD pfet_03v3 ad=0.9p pd=4.9u as=0.9p ps=4.9u w=2u l=0.28u
M1 Y A VSS VSS nfet_03v3 ad=0.45p pd=2.9u as=0.45p ps=2.9u w=1u l=0.28u
C0 VDD A 0.28836f
C1 VDD Y 0.93857f
C2 A Y 0.05104f
C3 Y VSS 1.82953f
C4 A VSS 0.612f
C5 VDD VSS 4.93225f
.ends

.subckt OR A B Y VDD VSS a_651_86# a_505_n286#
M0 VDD B a_651_86# VDD pfet_03v3 ad=0.9p pd=4.9u as=0.53p ps=2.53u w=2u l=0.28u
M1 VSS A a_505_n286# VSS nfet_03v3 ad=0.265p pd=1.53u as=0.45p ps=2.9u w=1u l=0.28u
M2 a_651_86# A a_505_n286# VDD pfet_03v3 ad=0.53p pd=2.53u as=0.9p ps=4.9u w=2u l=0.28u
M3 a_505_n286# B VSS VSS nfet_03v3 ad=0.45p pd=2.9u as=0.265p ps=1.53u w=1u l=0.28u
M4 Y a_505_n286# VSS VSS nfet_03v3 ad=0.625p pd=3.25u as=0.625p ps=3.25u w=1u l=0.28u
M5 Y a_505_n286# VDD VDD pfet_03v3 ad=1.25p pd=5.25u as=1.25p ps=5.25u w=2u l=0.28u
C0 a_505_n286# a_651_86# 0.02609f
C1 a_505_n286# VDD 0.60195f
C2 a_505_n286# A 0.06265f
C3 a_505_n286# B 0.06594f
C4 a_505_n286# Y 0.12779f
C5 a_651_86# VDD 0.03536f
C6 a_651_86# Y 0
C7 VDD A 0.59831f
C8 VDD B 0.11999f
C9 VDD Y 0.63118f
C10 A B 0.05231f
C11 A Y 0
C12 B Y 0
C13 Y VSS 0.74439f
C14 B VSS 1.30453f
C15 A VSS 0.5295f
C16 VDD VSS 6.17565f
C17 a_651_86# VSS 0.00201f
C18 a_505_n286# VSS 0.79095f
.ends

.subckt XOR A B Y VDD VSS a_1155_195# a_1609_n395# m1_n57_n1110# m2_n57_n1110# a_1009_n395#
+ a_1463_195#
M0 Y a_1009_n395# a_1463_195# VDD pfet_03v3 ad=1.25p pd=5.25u as=0.705p ps=2.705u w=2u l=0.28u
M1 a_1463_195# B VDD VDD pfet_03v3 ad=0.705p pd=2.705u as=0.53p ps=2.53u w=2u l=0.28u
M2 VDD A a_1463_195# VDD pfet_03v3 ad=0.53p pd=2.53u as=0.9p ps=4.9u w=2u l=0.28u
M3 a_1009_n395# B VSS VSS nfet_03v3 ad=0.45p pd=2.9u as=0.265p ps=1.53u w=1u l=0.28u
M4 a_1609_n395# A Y VSS nfet_03v3 ad=0.265p pd=1.53u as=0.45p ps=2.9u w=1u l=0.28u
M5 VDD B a_1155_195# VDD pfet_03v3 ad=0.9p pd=4.9u as=0.53p ps=2.53u w=2u l=0.28u
M6 VSS B a_1609_n395# VSS nfet_03v3 ad=0.3525p pd=1.705u as=0.265p ps=1.53u w=1u l=0.28u
M7 a_1155_195# A a_1009_n395# VDD pfet_03v3 ad=0.53p pd=2.53u as=0.9p ps=4.9u w=2u l=0.28u
M8 VSS A a_1009_n395# VSS nfet_03v3 ad=0.265p pd=1.53u as=0.45p ps=2.9u w=1u l=0.28u
M9 Y a_1009_n395# VSS VSS nfet_03v3 ad=0.625p pd=3.25u as=0.3525p ps=1.705u w=1u l=0.28u
C0 a_1009_n395# a_1155_195# 0.02315f
C1 a_1009_n395# a_1463_195# 0.49044f
C2 a_1009_n395# m1_n57_n1110# 0.01171f
C3 a_1009_n395# m2_n57_n1110# 0.00242f
C4 a_1009_n395# VDD 0.63712f
C5 a_1009_n395# A 0.09858f
C6 a_1009_n395# B 0.12558f
C7 a_1009_n395# Y 0.97225f
C8 a_1155_195# a_1463_195# 0
C9 a_1155_195# VDD 0.03214f
C10 a_1463_195# m2_n57_n1110# 0
C11 a_1463_195# VDD 0.83682f
C12 a_1463_195# A 0.04667f
C13 a_1463_195# B 0.04491f
C14 a_1463_195# Y 0.14545f
C15 a_1609_n395# VDD 0
C16 a_1609_n395# Y 0.01483f
C17 m1_n57_n1110# m2_n57_n1110# 0.55172f
C18 m1_n57_n1110# VDD 0.14282f
C19 m1_n57_n1110# A 0.07093f
C20 m1_n57_n1110# B 0.06992f
C21 m2_n57_n1110# VDD 0.13215f
C22 m2_n57_n1110# A 0.01915f
C23 m2_n57_n1110# B 0.01901f
C24 m2_n57_n1110# Y 0
C25 VDD A 1.14567f
C26 VDD B 0.31693f
C27 VDD Y 0.57323f
C28 A B 0.19007f
C29 A Y 0.03021f
C30 B Y 0.03299f
C31 Y VSS 1.00565f
C32 B VSS 2.34945f
C33 A VSS 1.14285f
C34 VDD VSS 8.40014f
C35 m2_n57_n1110# VSS 0.80082f
C36 m1_n57_n1110# VSS 1.26958f
C37 a_1609_n395# VSS 0.01427f
C38 a_1463_195# VSS 0.00312f
C39 a_1155_195# VSS 0.0013f
C40 a_1009_n395# VSS 0.69678f
.ends

.subckt NOR A B Y VDD VSS a_657_86#
M0 Y B VSS VSS nfet_03v3 ad=0.45p pd=2.9u as=0.265p ps=1.53u w=1u l=0.28u
M1 VDD B a_657_86# VDD pfet_03v3 ad=0.9p pd=4.9u as=0.53p ps=2.53u w=2u l=0.28u
M2 a_657_86# A Y VDD pfet_03v3 ad=0.53p pd=2.53u as=0.9p ps=4.9u w=2u l=0.28u
M3 VSS A Y VSS nfet_03v3 ad=0.265p pd=1.53u as=0.45p ps=2.9u w=1u l=0.28u
C0 a_657_86# VDD 0.03576f
C1 a_657_86# Y 0.02609f
C2 VDD A 0.60539f
C3 VDD B 0.12548f
C4 VDD Y 0.91931f
C5 A B 0.05236f
C6 A Y 0.06282f
C7 B Y 0.05677f
C8 Y VSS 1.96192f
C9 B VSS 1.30846f
C10 A VSS 0.52794f
C11 VDD VSS 6.11409f
C12 a_657_86# VSS 0.00205f
.ends

.subckt ALU181 A0 A1 A2 A3 B0 B1 B2 B3 S0 S1 S2 S3 M Cn F0 F1 F2 F3 AEQB P_N G_N Cn4
+ VDD VSS
XAND_e01 F0 F1 AND_eq/A VDD VSS AND_e01/a_323_n286# AND_e01/a_469_n286# AND
XAND_e23 F2 F3 AND_eq/B VDD VSS AND_e23/a_323_n286# AND_e23/a_469_n286# AND
XNAND_a4_0 B0 S3 NAND_v0/B VDD VSS NAND_a4_0/a_512_n286# NAND
XNOT_nb0 B0 NOT_nb0/Y VDD VSS NOT
XNAND_a4_1 B1 S3 NAND_v1/B VDD VSS NAND_a4_1/a_512_n286# NAND
XNOT_nb1 B1 NOT_nb1/Y VDD VSS NOT
XNAND_a4_3 B3 S3 NAND_v3/B VDD VSS NAND_a4_3/a_512_n286# NAND
XNAND_a4_2 B2 S3 NAND_v2/B VDD VSS NAND_a4_2/a_512_n286# NAND
XNOT_nb2 B2 NOT_nb2/Y VDD VSS NOT
XOR_p0 A0 OR_p0/B OR_p0/Y VDD VSS OR_p0/a_651_86# OR_p0/a_505_n286# OR
XNOT_nb3 B3 NOT_nb3/Y VDD VSS NOT
XOR_p1 A1 OR_p1/B OR_p1/Y VDD VSS OR_p1/a_651_86# OR_p1/a_505_n286# OR
XNAND_a2_1 NOT_nb1/Y S1 NAND_u1/B VDD VSS NAND_a2_1/a_512_n286# NAND
XNAND_a2_0 NOT_nb0/Y S1 NAND_u0/B VDD VSS NAND_a2_0/a_512_n286# NAND
XOR_p3 A3 OR_p3/B OR_p3/Y VDD VSS OR_p3/a_651_86# OR_p3/a_505_n286# OR
XOR_p2 A2 OR_p2/B OR_p2/Y VDD VSS OR_p2/a_651_86# OR_p2/a_505_n286# OR
XNAND_a2_2 NOT_nb2/Y S1 NAND_u2/B VDD VSS NAND_a2_2/a_512_n286# NAND
XXOR_h0 OR_p0/Y XOR_h0/B XOR_h0/Y VDD VSS XOR_h0/a_1155_195# XOR_h0/a_1609_n395# XOR_h0/m1_n57_n1110#
+ XOR_h0/m2_n57_n1110# XOR_h0/a_1009_n395# XOR_h0/a_1463_195# XOR
XNAND_a2_3 NOT_nb3/Y S1 NAND_u3/B VDD VSS NAND_a2_3/a_512_n286# NAND
XXOR_h1 OR_p1/Y XOR_h1/B XOR_h1/Y VDD VSS XOR_h1/a_1155_195# XOR_h1/a_1609_n395# XOR_h1/m1_n57_n1110#
+ XOR_h1/m2_n57_n1110# XOR_h1/a_1009_n395# XOR_h1/a_1463_195# XOR
XNOT_ncout OR_cy3/Y Cn4 VDD VSS NOT
XXOR_h2 OR_p2/Y XOR_h2/B XOR_h2/Y VDD VSS XOR_h2/a_1155_195# XOR_h2/a_1609_n395# XOR_h2/m1_n57_n1110#
+ XOR_h2/m2_n57_n1110# XOR_h2/a_1009_n395# XOR_h2/a_1463_195# XOR
XXOR_f0 XOR_h0/Y OR_k0/Y F0 VDD VSS XOR_f0/a_1155_195# XOR_f0/a_1609_n395# XOR_f0/m1_n57_n1110#
+ XOR_f0/m2_n57_n1110# XOR_f0/a_1009_n395# XOR_f0/a_1463_195# XOR
XOR_k0 M OR_k0/B OR_k0/Y VDD VSS OR_k0/a_651_86# OR_k0/a_505_n286# OR
XXOR_h3 OR_p3/Y XOR_h3/B XOR_h3/Y VDD VSS XOR_h3/a_1155_195# XOR_h3/a_1609_n395# XOR_h3/m1_n57_n1110#
+ XOR_h3/m2_n57_n1110# XOR_h3/a_1009_n395# XOR_h3/a_1463_195# XOR
XXOR_f1 XOR_h1/Y OR_k1/Y F1 VDD VSS XOR_f1/a_1155_195# XOR_f1/a_1609_n395# XOR_f1/m1_n57_n1110#
+ XOR_f1/m2_n57_n1110# XOR_f1/a_1009_n395# XOR_f1/a_1463_195# XOR
XOR_k1 M OR_k1/B OR_k1/Y VDD VSS OR_k1/a_651_86# OR_k1/a_505_n286# OR
XXOR_f3 XOR_h3/Y OR_k3/Y F3 VDD VSS XOR_f3/a_1155_195# XOR_f3/a_1609_n395# XOR_f3/m1_n57_n1110#
+ XOR_f3/m2_n57_n1110# XOR_f3/a_1009_n395# XOR_f3/a_1463_195# XOR
XXOR_f2 XOR_h2/Y OR_k2/Y F2 VDD VSS XOR_f2/a_1155_195# XOR_f2/a_1609_n395# XOR_f2/m1_n57_n1110#
+ XOR_f2/m2_n57_n1110# XOR_f2/a_1009_n395# XOR_f2/a_1463_195# XOR
XOR_k2 M OR_k2/B OR_k2/Y VDD VSS OR_k2/a_651_86# OR_k2/a_505_n286# OR
XOR_k3 M OR_k3/B OR_k3/Y VDD VSS OR_k3/a_651_86# OR_k3/a_505_n286# OR
XNAND_pg NAND_pg/A NAND_pg/B P_N VDD VSS NAND_pg/a_512_n286# NAND
XNAND_a3_0 NOT_nb0/Y S2 NAND_v0/A VDD VSS NAND_a3_0/a_512_n286# NAND
XAND_q1 OR_p1/Y XOR_h0/B OR_gr1/B VDD VSS AND_q1/a_323_n286# AND_q1/a_469_n286# AND
XNAND_a3_1 NOT_nb1/Y S2 NAND_v1/A VDD VSS NAND_a3_1/a_512_n286# NAND
XAND_pc0 OR_p0/Y OR_k0/B OR_cy0/B VDD VSS AND_pc0/a_323_n286# AND_pc0/a_469_n286#
+ AND
XAND_q3 OR_p3/Y OR_gr2/Y NOR_gg/B VDD VSS AND_q3/a_323_n286# AND_q3/a_469_n286# AND
XAND_q2 OR_p2/Y OR_gr1/Y OR_gr2/B VDD VSS AND_q2/a_323_n286# AND_q2/a_469_n286# AND
XNAND_a3_2 NOT_nb2/Y S2 NAND_v2/A VDD VSS NAND_a3_2/a_512_n286# NAND
XAND_pc1 OR_p1/Y OR_k1/B OR_cy1/B VDD VSS AND_pc1/a_323_n286# AND_pc1/a_469_n286#
+ AND
XNAND_a3_3 NOT_nb3/Y S2 NAND_v3/A VDD VSS NAND_a3_3/a_512_n286# NAND
XAND_pc2 OR_p2/Y OR_k2/B OR_cy2/B VDD VSS AND_pc2/a_323_n286# AND_pc2/a_469_n286#
+ AND
XNAND_v1 NAND_v1/A NAND_v1/B AND_g1/B VDD VSS NAND_v1/a_512_n286# NAND
XNAND_v0 NAND_v0/A NAND_v0/B AND_g0/B VDD VSS NAND_v0/a_512_n286# NAND
XNAND_u0 NAND_u0/A NAND_u0/B OR_p0/B VDD VSS NAND_u0/a_512_n286# NAND
XNAND_a1_0 B0 S0 NAND_u0/A VDD VSS NAND_a1_0/a_512_n286# NAND
XAND_eq AND_eq/A AND_eq/B AEQB VDD VSS AND_eq/a_323_n286# AND_eq/a_469_n286# AND
XAND_pc3 OR_p3/Y OR_k3/B OR_cy3/B VDD VSS AND_pc3/a_323_n286# AND_pc3/a_469_n286#
+ AND
XNAND_v2 NAND_v2/A NAND_v2/B AND_g2/B VDD VSS NAND_v2/a_512_n286# NAND
XNAND_u1 NAND_u1/A NAND_u1/B OR_p1/B VDD VSS NAND_u1/a_512_n286# NAND
XNAND_a1_1 B1 S0 NAND_u1/A VDD VSS NAND_a1_1/a_512_n286# NAND
XNAND_v3 NAND_v3/A NAND_v3/B AND_g3/B VDD VSS NAND_v3/a_512_n286# NAND
XNAND_u2 NAND_u2/A NAND_u2/B OR_p2/B VDD VSS NAND_u2/a_512_n286# NAND
XNAND_a1_2 B2 S0 NAND_u2/A VDD VSS NAND_a1_2/a_512_n286# NAND
XNOT_ncn Cn OR_k0/B VDD VSS NOT
XAND_pp23 OR_p2/Y OR_p3/Y NAND_pg/B VDD VSS AND_pp23/a_323_n286# AND_pp23/a_469_n286#
+ AND
XAND_pp01 OR_p0/Y OR_p1/Y NAND_pg/A VDD VSS AND_pp01/a_323_n286# AND_pp01/a_469_n286#
+ AND
XNAND_u3 NAND_u3/A NAND_u3/B OR_p3/B VDD VSS NAND_u3/a_512_n286# NAND
XNAND_a1_3 B3 S0 NAND_u3/A VDD VSS NAND_a1_3/a_512_n286# NAND
XNOR_gg XOR_h3/B NOR_gg/B G_N VDD VSS NOR_gg/a_657_86# NOR
XOR_cy0 XOR_h0/B OR_cy0/B OR_k1/B VDD VSS OR_cy0/a_651_86# OR_cy0/a_505_n286# OR
XOR_gr1 XOR_h1/B OR_gr1/B OR_gr1/Y VDD VSS OR_gr1/a_651_86# OR_gr1/a_505_n286# OR
XOR_cy1 XOR_h1/B OR_cy1/B OR_k2/B VDD VSS OR_cy1/a_651_86# OR_cy1/a_505_n286# OR
XOR_gr2 XOR_h2/B OR_gr2/B OR_gr2/Y VDD VSS OR_gr2/a_651_86# OR_gr2/a_505_n286# OR
XOR_cy2 XOR_h2/B OR_cy2/B OR_k3/B VDD VSS OR_cy2/a_651_86# OR_cy2/a_505_n286# OR
XAND_g0 A0 AND_g0/B XOR_h0/B VDD VSS AND_g0/a_323_n286# AND_g0/a_469_n286# AND
XOR_cy3 XOR_h3/B OR_cy3/B OR_cy3/Y VDD VSS OR_cy3/a_651_86# OR_cy3/a_505_n286# OR
XAND_g2 A2 AND_g2/B XOR_h2/B VDD VSS AND_g2/a_323_n286# AND_g2/a_469_n286# AND
XAND_g1 A1 AND_g1/B XOR_h1/B VDD VSS AND_g1/a_323_n286# AND_g1/a_469_n286# AND
XAND_g3 A3 AND_g3/B XOR_h3/B VDD VSS AND_g3/a_323_n286# AND_g3/a_469_n286# AND
C0 AND_e01/a_323_n286# AND_eq/A 0
C1 AND_e01/a_323_n286# F0 0.01646f
C2 AND_e01/a_323_n286# F1 0.00607f
C3 AND_e01/a_323_n286# VDD 0
C4 AND_e01/a_323_n286# G_N 0.05193f
C5 AND_e01/a_469_n286# F1 0.00192f
C6 AND_e01/a_469_n286# G_N 0.00288f
C7 AND_eq/A AND_e23/a_323_n286# 0.04515f
C8 AND_eq/A AND_e23/a_469_n286# 0.00209f
C9 AND_eq/A AND_eq/B 0.28839f
C10 AND_eq/A F0 0.11842f
C11 AND_eq/A F1 0.00643f
C12 AND_eq/A F3 0.00672f
C13 AND_eq/A F2 0.70252f
C14 AND_eq/A AND_eq/a_323_n286# 0.00419f
C15 AND_eq/A AEQB 0
C16 AND_eq/A VDD 0.34443f
C17 AND_eq/A G_N 0.5654f
C18 AND_e23/a_323_n286# AND_eq/B 0.00106f
C19 AND_e23/a_323_n286# F0 0.0059f
C20 AND_e23/a_323_n286# F3 0.0016f
C21 AND_e23/a_323_n286# F2 0.01378f
C22 AND_e23/a_323_n286# VDD 0
C23 AND_e23/a_323_n286# G_N 0.02068f
C24 AND_e23/a_469_n286# F0 0
C25 AND_e23/a_469_n286# G_N 0.00231f
C26 AND_eq/B F3 0.09205f
C27 AND_eq/B F2 0.30069f
C28 AND_eq/B AND_eq/a_323_n286# 0.00784f
C29 AND_eq/B AND_eq/a_469_n286# 0
C30 AND_eq/B AEQB 0
C31 AND_eq/B VDD 0.00963f
C32 AND_eq/B G_N 0.2156f
C33 NAND_a4_0/a_512_n286# S3 0
C34 NAND_a4_0/a_512_n286# XOR_h0/B 0.00209f
C35 S3 NAND_v0/B 0.00102f
C36 S3 B0 0.71656f
C37 S3 NOT_nb0/Y 0.30699f
C38 S3 NAND_v1/B 0
C39 S3 B1 1.25861f
C40 S3 NOT_nb1/Y 1.43372f
C41 S3 NAND_v3/B -0
C42 S3 B2 0.03636f
C43 S3 NOT_nb2/Y 0.02968f
C44 S3 OR_p0/a_505_n286# 0.01313f
C45 S3 OR_p0/a_651_86# 0.0041f
C46 S3 A0 7.66195f
C47 S3 OR_p0/Y 5.96011f
C48 S3 B3 0.03106f
C49 S3 A1 0.02659f
C50 S3 OR_p1/Y 0.08382f
C51 S3 NAND_a2_0/a_512_n286# 0.00184f
C52 S3 S1 0.47301f
C53 S3 NAND_u0/B 0.1326f
C54 S3 A3 0.0041f
C55 S3 A2 0.038f
C56 S3 OR_p2/Y 0.02858f
C57 S3 XOR_h0/a_1009_n395# 0.00247f
C58 S3 XOR_h0/a_1463_195# 0.00381f
C59 S3 XOR_h0/a_1609_n395# 0
C60 S3 XOR_h0/Y 0.01256f
C61 S3 XOR_h1/Y 0.0497f
C62 S3 XOR_h2/Y 0.02355f
C63 S3 F0 3.79094f
C64 S3 M 0.10651f
C65 S3 XOR_f1/m1_n57_n1110# 0.00174f
C66 S3 XOR_f1/m2_n57_n1110# 0.01319f
C67 S3 F1 0.08106f
C68 S3 OR_k1/a_505_n286# 0
C69 S3 OR_k1/Y 0.29123f
C70 S3 XOR_f2/m1_n57_n1110# 0
C71 S3 XOR_f2/m2_n57_n1110# 0
C72 S3 OR_k2/a_505_n286# 0
C73 S3 OR_k2/Y 0.00941f
C74 S3 NAND_a3_0/a_512_n286# 0.00298f
C75 S3 S2 1.48509f
C76 S3 NAND_v0/A 0.29708f
C77 S3 NAND_v1/A 0.04149f
C78 S3 NAND_v2/A 0.01423f
C79 S3 OR_cy1/B 0.12633f
C80 S3 NAND_v3/A 0.01491f
C81 S3 OR_p0/B 0.05721f
C82 S3 NAND_a1_0/a_512_n286# 0.00184f
C83 S3 S0 0.12042f
C84 S3 NAND_u0/A 0.3076f
C85 S3 OR_cy3/B 0.01758f
C86 S3 OR_p1/B 1.39378f
C87 S3 NAND_a1_1/a_512_n286# 0
C88 S3 NAND_u1/A 0.0495f
C89 S3 NAND_u2/A 0
C90 S3 VDD 2.74463f
C91 S3 Cn 0.15967f
C92 S3 OR_k0/B 0.76898f
C93 S3 OR_p3/B 0.0297f
C94 S3 OR_k1/B 0.03891f
C95 S3 OR_k2/B 0.03536f
C96 S3 XOR_h0/B 0.34202f
C97 S3 XOR_h2/B 0.0232f
C98 S3 XOR_h1/B 0.04236f
C99 NAND_v0/B A0 0.03355f
C100 NAND_v0/B NAND_v0/A 0.02715f
C101 NAND_v0/B NAND_v0/a_512_n286# 0
C102 NAND_v0/B AND_g0/B 0.00428f
C103 NAND_v0/B VDD 0.01506f
C104 NAND_v0/B XOR_h0/B 0.26906f
C105 B0 NOT_nb0/Y 5.41858f
C106 B0 OR_p0/a_505_n286# 0
C107 B0 A0 4.03582f
C108 B0 OR_p0/Y 0.04188f
C109 B0 S1 0.04236f
C110 B0 NAND_u0/B 0.00422f
C111 B0 S2 1.62498f
C112 B0 NAND_v0/A 0.09262f
C113 B0 OR_p0/B 0.00436f
C114 B0 S0 0.05745f
C115 B0 NAND_u0/A 1.25006f
C116 B0 VDD 3.54804f
C117 B0 Cn 0.24933f
C118 B0 OR_k0/B 0.5688f
C119 B0 XOR_h0/B 0.05491f
C120 NOT_nb0/Y OR_p0/a_505_n286# 0.00176f
C121 NOT_nb0/Y A0 2.70162f
C122 NOT_nb0/Y OR_p0/Y 0.04767f
C123 NOT_nb0/Y S1 0.1369f
C124 NOT_nb0/Y NAND_u0/B 0.00305f
C125 NOT_nb0/Y S2 0.29206f
C126 NOT_nb0/Y OR_p0/B 0.0033f
C127 NOT_nb0/Y S0 0.10567f
C128 NOT_nb0/Y NAND_u0/A 0.12174f
C129 NOT_nb0/Y VDD 2.24163f
C130 NOT_nb0/Y OR_k0/B 0.00425f
C131 NOT_nb0/Y XOR_h0/B 0.01308f
C132 NAND_a4_1/a_512_n286# NOT_nb1/Y 0.00216f
C133 NAND_a4_1/a_512_n286# OR_p0/Y 0.001f
C134 NAND_a4_1/a_512_n286# F1 0.00209f
C135 NAND_v1/B B1 0
C136 NAND_v1/B NOT_nb1/Y 0.32873f
C137 NAND_v1/B OR_p0/Y 0.00151f
C138 NAND_v1/B A1 0.0554f
C139 NAND_v1/B OR_p1/Y 0.02655f
C140 NAND_v1/B S1 0.14806f
C141 NAND_v1/B F0 0
C142 NAND_v1/B M 0.00438f
C143 NAND_v1/B F1 0.22027f
C144 NAND_v1/B NAND_v1/A 0.03197f
C145 NAND_v1/B AND_g1/B 0.00309f
C146 NAND_v1/B S0 0
C147 NAND_v1/B OR_p1/B 0.21714f
C148 NAND_v1/B VDD 0.01696f
C149 B1 NOT_nb1/Y 0.74734f
C150 B1 OR_p0/Y 0.11086f
C151 B1 A1 0.04463f
C152 B1 OR_p1/Y 1.29989f
C153 B1 S1 0.0478f
C154 B1 XOR_h0/a_1009_n395# 0.05418f
C155 B1 XOR_h0/a_1155_195# 0.00106f
C156 B1 XOR_h0/a_1463_195# 0.01119f
C157 B1 XOR_h0/a_1609_n395# 0.00238f
C158 B1 XOR_h0/m1_n57_n1110# 0.00903f
C159 B1 XOR_h0/m2_n57_n1110# 0.09423f
C160 B1 XOR_h0/Y 0.26652f
C161 B1 XOR_f0/a_1009_n395# 0.03436f
C162 B1 XOR_f0/a_1463_195# 0.00278f
C163 B1 XOR_f0/a_1609_n395# 0.0034f
C164 B1 XOR_f0/m1_n57_n1110# 0.00828f
C165 B1 XOR_f0/m2_n57_n1110# 0.07951f
C166 B1 OR_k0/Y 0.10625f
C167 B1 F0 3.34027f
C168 B1 OR_k0/a_505_n286# 0.02803f
C169 B1 OR_k0/a_651_86# 0.00309f
C170 B1 M 2.29484f
C171 B1 F1 0.03104f
C172 B1 S2 0.12691f
C173 B1 NAND_v1/A 0.04192f
C174 B1 AND_pc0/a_323_n286# 0.01065f
C175 B1 AND_pc0/a_469_n286# 0.00231f
C176 B1 OR_cy0/B 0.06393f
C177 B1 S0 4.07146f
C178 B1 OR_p1/B 0.03602f
C179 B1 NAND_u1/A 0
C180 B1 VDD 1.07781f
C181 B1 OR_k0/B 0.33946f
C182 B1 OR_cy0/a_505_n286# 0.00835f
C183 B1 OR_k1/B 0.26022f
C184 B1 XOR_h0/B 2.36437f
C185 NOT_nb1/Y OR_p0/Y 0.04023f
C186 NOT_nb1/Y A1 0.31115f
C187 NOT_nb1/Y OR_p1/Y 0.14527f
C188 NOT_nb1/Y S1 0.10866f
C189 NOT_nb1/Y XOR_h1/a_1009_n395# 0.02415f
C190 NOT_nb1/Y XOR_h1/a_1463_195# 0.00201f
C191 NOT_nb1/Y XOR_h1/a_1609_n395# 0.00227f
C192 NOT_nb1/Y XOR_h1/m1_n57_n1110# 0.00838f
C193 NOT_nb1/Y XOR_h1/m2_n57_n1110# 0.0961f
C194 NOT_nb1/Y XOR_h1/Y 0.13435f
C195 NOT_nb1/Y F0 0.72736f
C196 NOT_nb1/Y M 0.05774f
C197 NOT_nb1/Y F1 1.55003f
C198 NOT_nb1/Y OR_k1/a_505_n286# 0.00649f
C199 NOT_nb1/Y S2 0.58747f
C200 NOT_nb1/Y NAND_a3_1/a_512_n286# 0.00216f
C201 NOT_nb1/Y NAND_v1/A 0.19842f
C202 NOT_nb1/Y NAND_v1/a_512_n286# 0.00216f
C203 NOT_nb1/Y AND_g1/B 0.33742f
C204 NOT_nb1/Y S0 1.21249f
C205 NOT_nb1/Y OR_p1/B 2.07512f
C206 NOT_nb1/Y NAND_a1_1/a_512_n286# 0
C207 NOT_nb1/Y NAND_u1/A 0.1885f
C208 NOT_nb1/Y VDD 1.15515f
C209 NOT_nb1/Y OR_k1/B 1.65653f
C210 NOT_nb1/Y XOR_h0/B 0.0905f
C211 NOT_nb1/Y AND_g1/a_323_n286# 0.01518f
C212 NOT_nb1/Y AND_g1/a_469_n286# 0.00216f
C213 NOT_nb1/Y XOR_h1/B 0.25788f
C214 NAND_a4_3/a_512_n286# OR_p1/Y 0.00114f
C215 NAND_a4_3/a_512_n286# OR_cy3/B 0.00209f
C216 NAND_v3/B OR_p0/Y 0
C217 NAND_v3/B B3 0
C218 NAND_v3/B NOT_nb3/Y 0.00438f
C219 NAND_v3/B OR_p1/Y 0.0018f
C220 NAND_v3/B A3 0.03369f
C221 NAND_v3/B OR_p2/Y 0.0051f
C222 NAND_v3/B F0 0
C223 NAND_v3/B F1 0
C224 NAND_v3/B F2 0.181f
C225 NAND_v3/B NAND_v3/A 0.03332f
C226 NAND_v3/B OR_cy3/B 0.27075f
C227 NAND_v3/B NAND_v3/a_512_n286# 0
C228 NAND_v3/B AND_g3/B 0.00444f
C229 NAND_v3/B VDD 0.01763f
C230 NAND_a4_2/a_512_n286# S1 0.00151f
C231 NAND_a4_2/a_512_n286# A2 0.00157f
C232 NAND_a4_2/a_512_n286# OR_cy1/B 0.00166f
C233 NAND_v2/B S1 0.03072f
C234 NAND_v2/B A2 0.10555f
C235 NAND_v2/B NAND_v2/A 0.0323f
C236 NAND_v2/B OR_cy1/B 0.19438f
C237 NAND_v2/B NAND_v2/a_512_n286# 0
C238 NAND_v2/B AND_g2/B 0.00461f
C239 NAND_v2/B VDD 0.01812f
C240 NAND_v2/B XOR_h2/B 0.00224f
C241 B2 NOT_nb2/Y 1.58773f
C242 B2 OR_p0/Y 0.05883f
C243 B2 OR_p1/Y 0.37563f
C244 B2 S1 0.03215f
C245 B2 OR_p2/a_505_n286# 0.03059f
C246 B2 OR_p2/a_651_86# 0
C247 B2 A2 1.622f
C248 B2 OR_p2/Y 1.24246f
C249 B2 NAND_a2_2/a_512_n286# 0.0034f
C250 B2 NAND_u2/B 0.33764f
C251 B2 F0 0.029f
C252 B2 M 0.27911f
C253 B2 F1 0.03704f
C254 B2 S2 0.11443f
C255 B2 NAND_a3_2/a_512_n286# 0
C256 B2 NAND_v2/A 0.09375f
C257 B2 OR_cy1/B 2.37465f
C258 B2 S0 0.16557f
C259 B2 NAND_u2/a_512_n286# 0.0034f
C260 B2 OR_p2/B 0.31199f
C261 B2 NAND_a1_2/a_512_n286# 0.00382f
C262 B2 NAND_u2/A 0.42923f
C263 B2 VDD 1.12342f
C264 B2 OR_cy1/a_505_n286# 0.0368f
C265 B2 OR_cy1/a_651_86# 0.00386f
C266 B2 OR_k2/B 0.13701f
C267 B2 XOR_h0/B 0.04098f
C268 B2 XOR_h1/B 1.14918f
C269 NOT_nb2/Y OR_p0/Y 0.02937f
C270 NOT_nb2/Y OR_p1/Y 0.02923f
C271 NOT_nb2/Y S1 0.02061f
C272 NOT_nb2/Y OR_p2/a_505_n286# 0.00328f
C273 NOT_nb2/Y OR_p2/a_651_86# 0.00107f
C274 NOT_nb2/Y A2 2.76287f
C275 NOT_nb2/Y OR_p2/Y 1.04935f
C276 NOT_nb2/Y NAND_a2_2/a_512_n286# 0
C277 NOT_nb2/Y NAND_u2/B 0.12869f
C278 NOT_nb2/Y F0 0.03115f
C279 NOT_nb2/Y M 0.03236f
C280 NOT_nb2/Y F1 0.05179f
C281 NOT_nb2/Y S2 0.01165f
C282 NOT_nb2/Y OR_cy1/B 0.01305f
C283 NOT_nb2/Y S0 0.01084f
C284 NOT_nb2/Y NAND_u2/a_512_n286# 0
C285 NOT_nb2/Y OR_p2/B 0.06105f
C286 NOT_nb2/Y NAND_u2/A 0.34122f
C287 NOT_nb2/Y VDD 1.59632f
C288 NOT_nb2/Y OR_k2/B 0
C289 NOT_nb2/Y XOR_h0/B 0.0317f
C290 NOT_nb2/Y XOR_h1/B 3.7694f
C291 OR_p0/a_505_n286# A0 0.00778f
C292 OR_p0/a_505_n286# OR_p0/Y 0.03223f
C293 OR_p0/a_505_n286# S2 0.01375f
C294 OR_p0/a_505_n286# OR_p0/B 0.00134f
C295 OR_p0/a_505_n286# VDD 0
C296 OR_p0/a_651_86# A0 0.00223f
C297 OR_p0/a_651_86# OR_p0/Y 0.00345f
C298 OR_p0/a_651_86# S2 0
C299 A0 OR_p0/Y 0.06022f
C300 A0 S1 0.04072f
C301 A0 NAND_u0/B 0.02377f
C302 A0 S2 0.09416f
C303 A0 NAND_v0/A 1.43978f
C304 A0 AND_g0/B 0.02908f
C305 A0 OR_p0/B 0.0225f
C306 A0 S0 0.0426f
C307 A0 NAND_u0/A 1.37994f
C308 A0 VDD 3.34197f
C309 A0 Cn 0.09018f
C310 A0 OR_k0/B 0.05573f
C311 A0 XOR_h0/B 1.84099f
C312 OR_p0/Y B3 0.04201f
C313 OR_p0/Y NOT_nb3/Y 0.03209f
C314 OR_p0/Y A1 0.02741f
C315 OR_p0/Y OR_p1/Y 5.03044f
C316 OR_p0/Y S1 0.09478f
C317 OR_p0/Y NAND_u0/B 0.00564f
C318 OR_p0/Y A3 0.03022f
C319 OR_p0/Y OR_p3/Y 0.03096f
C320 OR_p0/Y A2 0.02831f
C321 OR_p0/Y OR_p2/Y 0.02858f
C322 OR_p0/Y XOR_h0/a_1009_n395# 0.00848f
C323 OR_p0/Y XOR_h0/a_1155_195# 0.0028f
C324 OR_p0/Y XOR_h0/a_1463_195# 0.011f
C325 OR_p0/Y XOR_h0/m1_n57_n1110# 0.00751f
C326 OR_p0/Y XOR_h0/m2_n57_n1110# 0.10111f
C327 OR_p0/Y XOR_h0/Y 1.2916f
C328 OR_p0/Y Cn4 0.04036f
C329 OR_p0/Y XOR_h2/Y 0.02364f
C330 OR_p0/Y XOR_f0/a_1009_n395# 0.00314f
C331 OR_p0/Y XOR_f0/a_1155_195# 0
C332 OR_p0/Y XOR_f0/a_1463_195# 0.00405f
C333 OR_p0/Y XOR_f0/m1_n57_n1110# 0.00852f
C334 OR_p0/Y XOR_f0/m2_n57_n1110# 0.09626f
C335 OR_p0/Y OR_k0/Y 0.00439f
C336 OR_p0/Y F0 0.91888f
C337 OR_p0/Y OR_k0/a_505_n286# 0
C338 OR_p0/Y M 1.04252f
C339 OR_p0/Y F1 0.02807f
C340 OR_p0/Y XOR_f2/m1_n57_n1110# 0
C341 OR_p0/Y XOR_f2/m2_n57_n1110# 0
C342 OR_p0/Y OR_k2/a_505_n286# 0
C343 OR_p0/Y OR_k2/Y 0.01107f
C344 OR_p0/Y S2 0.77711f
C345 OR_p0/Y NAND_v0/A 0.00333f
C346 OR_p0/Y NAND_v1/A 0.13184f
C347 OR_p0/Y AND_pc0/a_323_n286# 0.00272f
C348 OR_p0/Y OR_cy0/B 0.18901f
C349 OR_p0/Y NOR_gg/B 0.05003f
C350 OR_p0/Y OR_cy1/B 0.0285f
C351 OR_p0/Y NAND_v3/A 0.03639f
C352 OR_p0/Y NAND_u0/a_512_n286# 0.00209f
C353 OR_p0/Y OR_p0/B 0.22961f
C354 OR_p0/Y S0 0.11817f
C355 OR_p0/Y NAND_u0/A 0.0103f
C356 OR_p0/Y OR_cy3/B 1.00263f
C357 OR_p0/Y OR_p1/B 0.04482f
C358 OR_p0/Y NAND_u2/A 0
C359 OR_p0/Y VDD 4.45817f
C360 OR_p0/Y OR_k0/B 0.00526f
C361 OR_p0/Y AND_pp01/a_323_n286# 0
C362 OR_p0/Y OR_p3/B 0.0297f
C363 OR_p0/Y OR_cy0/a_505_n286# 0.0034f
C364 OR_p0/Y OR_cy0/a_651_86# 0.00137f
C365 OR_p0/Y OR_k2/B 0.03537f
C366 OR_p0/Y XOR_h0/B 2.18459f
C367 OR_p0/Y XOR_h2/B 0.0232f
C368 OR_p0/Y XOR_h1/B 0.03054f
C369 OR_p0/Y XOR_h3/B 0.08619f
C370 B3 NOT_nb3/Y 1.66914f
C371 B3 OR_p1/Y 0.04067f
C372 B3 A3 1.3635f
C373 B3 OR_p3/Y 0.07982f
C374 B3 OR_p2/Y 0.65083f
C375 B3 XOR_h2/a_1009_n395# 0.05939f
C376 B3 XOR_h2/a_1155_195# 0.00401f
C377 B3 XOR_h2/a_1463_195# 0.02021f
C378 B3 XOR_h2/a_1609_n395# 0.00216f
C379 B3 XOR_h2/m1_n57_n1110# 0.00903f
C380 B3 XOR_h2/m2_n57_n1110# 0.10173f
C381 B3 XOR_h2/Y 0.14235f
C382 B3 F0 0.04782f
C383 B3 M 0.11627f
C384 B3 F1 0.06427f
C385 B3 XOR_f2/a_1009_n395# 0.01309f
C386 B3 XOR_f2/a_1155_195# 0.00404f
C387 B3 XOR_f2/a_1463_195# 0.01818f
C388 B3 XOR_f2/m1_n57_n1110# 0.00828f
C389 B3 XOR_f2/m2_n57_n1110# 0.06316f
C390 B3 F2 0.23422f
C391 B3 OR_k2/a_505_n286# 0.01313f
C392 B3 OR_k2/a_651_86# 0.0041f
C393 B3 OR_k2/Y 0.02553f
C394 B3 S2 1.09735f
C395 B3 NAND_a3_3/a_512_n286# 0
C396 B3 NAND_v3/A 0.04535f
C397 B3 AND_pc2/a_323_n286# 0.01937f
C398 B3 OR_cy2/B 0.0232f
C399 B3 S0 0.01618f
C400 B3 OR_cy3/B 0.03767f
C401 B3 VDD 1.87313f
C402 B3 OR_p3/B 7.29863f
C403 B3 NAND_u3/A 0
C404 B3 OR_k2/B 0.00711f
C405 B3 OR_cy2/a_505_n286# 0.01411f
C406 B3 OR_cy2/a_651_86# 0.00451f
C407 B3 OR_k3/B 0.24524f
C408 B3 XOR_h0/B 0.0352f
C409 B3 XOR_h2/B 6.19604f
C410 B3 XOR_h1/B 0.0352f
C411 NOT_nb3/Y OR_p1/Y 0.04061f
C412 NOT_nb3/Y S1 0.00703f
C413 NOT_nb3/Y A3 1.4128f
C414 NOT_nb3/Y OR_p3/Y 2.15427f
C415 NOT_nb3/Y OR_p2/Y 0.11587f
C416 NOT_nb3/Y F0 0.02858f
C417 NOT_nb3/Y M 0.2931f
C418 NOT_nb3/Y XOR_h3/a_1009_n395# 0.00314f
C419 NOT_nb3/Y XOR_h3/a_1155_195# 0
C420 NOT_nb3/Y XOR_h3/a_1463_195# 0.00405f
C421 NOT_nb3/Y XOR_h3/m1_n57_n1110# 0.00831f
C422 NOT_nb3/Y XOR_h3/m2_n57_n1110# 0.09506f
C423 NOT_nb3/Y XOR_h3/Y 0.45608f
C424 NOT_nb3/Y F1 0.0371f
C425 NOT_nb3/Y F2 0.46557f
C426 NOT_nb3/Y OR_k3/a_505_n286# 0.02262f
C427 NOT_nb3/Y OR_k3/a_651_86# 0.00239f
C428 NOT_nb3/Y OR_k3/Y 0.00784f
C429 NOT_nb3/Y S2 0.01097f
C430 NOT_nb3/Y NAND_v3/A 1.1933f
C431 NOT_nb3/Y S0 0.00387f
C432 NOT_nb3/Y OR_cy3/B 0.0866f
C433 NOT_nb3/Y AND_g3/B 0.00421f
C434 NOT_nb3/Y VDD 5.34399f
C435 NOT_nb3/Y OR_p3/B 0.46339f
C436 NOT_nb3/Y NAND_u3/A 0.10318f
C437 NOT_nb3/Y OR_k3/B 0.06345f
C438 NOT_nb3/Y XOR_h0/B 0.0371f
C439 NOT_nb3/Y XOR_h2/B 1.3575f
C440 NOT_nb3/Y XOR_h1/B 0.02858f
C441 NOT_nb3/Y AND_g3/a_323_n286# -0
C442 NOT_nb3/Y XOR_h3/B 0.04026f
C443 OR_p1/a_505_n286# A1 0.0332f
C444 OR_p1/a_505_n286# OR_p1/Y 0.00194f
C445 OR_p1/a_505_n286# S2 0.01497f
C446 OR_p1/a_505_n286# OR_p1/B 0
C447 OR_p1/a_505_n286# VDD 0.00142f
C448 OR_p1/a_651_86# A1 0.00638f
C449 OR_p1/a_651_86# S2 0.00135f
C450 OR_p1/a_651_86# VDD 0
C451 A1 OR_p1/Y 4.32655f
C452 A1 S1 0.17177f
C453 A1 F0 0.0232f
C454 A1 M 1.29142f
C455 A1 F1 1.54206f
C456 A1 S2 0.28129f
C457 A1 NAND_a3_1/a_512_n286# 0.00184f
C458 A1 NAND_v1/A 0.24776f
C459 A1 AND_g1/B 0.02078f
C460 A1 S0 0.03513f
C461 A1 OR_p1/B 0.03115f
C462 A1 VDD 1.48648f
C463 OR_p1/Y S1 0.08302f
C464 OR_p1/Y A3 0.03022f
C465 OR_p1/Y OR_p3/Y 0.18121f
C466 OR_p1/Y A2 0.0371f
C467 OR_p1/Y OR_p2/Y 0.94981f
C468 OR_p1/Y XOR_h1/a_1009_n395# 0.01591f
C469 OR_p1/Y XOR_h1/a_1155_195# 0.00567f
C470 OR_p1/Y XOR_h1/a_1463_195# 0.02308f
C471 OR_p1/Y XOR_h1/m1_n57_n1110# 0.00879f
C472 OR_p1/Y XOR_h1/m2_n57_n1110# 0.08111f
C473 OR_p1/Y XOR_h1/Y 1.37065f
C474 OR_p1/Y Cn4 0.07737f
C475 OR_p1/Y XOR_h2/Y 0.03419f
C476 OR_p1/Y F0 0.02445f
C477 OR_p1/Y M 3.01335f
C478 OR_p1/Y XOR_f1/a_1009_n395# 0.01174f
C479 OR_p1/Y XOR_f1/a_1155_195# 0.00439f
C480 OR_p1/Y XOR_f1/a_1463_195# 0.01596f
C481 OR_p1/Y XOR_f1/m1_n57_n1110# 0.00866f
C482 OR_p1/Y XOR_f1/m2_n57_n1110# 0.1036f
C483 OR_p1/Y F1 3.44594f
C484 OR_p1/Y OR_k1/a_505_n286# 0.01146f
C485 OR_p1/Y OR_k1/a_651_86# 0.00403f
C486 OR_p1/Y OR_k1/Y 0.01982f
C487 OR_p1/Y XOR_f2/m1_n57_n1110# 0.0012f
C488 OR_p1/Y XOR_f2/m2_n57_n1110# 0.00613f
C489 OR_p1/Y F2 0.04727f
C490 OR_p1/Y OR_k2/a_505_n286# 0
C491 OR_p1/Y OR_k2/Y 0.27586f
C492 OR_p1/Y NAND_pg/B 0.01558f
C493 OR_p1/Y P_N 0.02478f
C494 OR_p1/Y S2 0.17869f
C495 OR_p1/Y NAND_v1/A 1.34301f
C496 OR_p1/Y NOR_gg/B 1.80262f
C497 OR_p1/Y OR_cy1/B 0.04299f
C498 OR_p1/Y NAND_v3/A 0.28464f
C499 OR_p1/Y AND_g1/B 0.03305f
C500 OR_p1/Y S0 0.09888f
C501 OR_p1/Y OR_cy3/B 0.06557f
C502 OR_p1/Y OR_p1/B 0.00292f
C503 OR_p1/Y NAND_a1_2/a_512_n286# 0
C504 OR_p1/Y NAND_u2/A 0
C505 OR_p1/Y VDD 4.28873f
C506 OR_p1/Y AND_pp23/a_323_n286# 0.0173f
C507 OR_p1/Y AND_pp01/a_323_n286# 0.02449f
C508 OR_p1/Y AND_pp01/a_469_n286# 0.00108f
C509 OR_p1/Y NAND_pg/A 0.43612f
C510 OR_p1/Y OR_p3/B 0.03822f
C511 OR_p1/Y OR_k1/B 0.01051f
C512 OR_p1/Y OR_k2/B 0.04308f
C513 OR_p1/Y XOR_h0/B 0.04861f
C514 OR_p1/Y XOR_h2/B 0.03172f
C515 OR_p1/Y AND_g1/a_323_n286# 0.01288f
C516 OR_p1/Y XOR_h1/B 0.18844f
C517 OR_p1/Y XOR_h3/B 1.87144f
C518 NAND_a2_1/a_512_n286# S1 0
C519 NAND_a2_1/a_512_n286# F0 0.0034f
C520 NAND_a2_1/a_512_n286# NAND_u1/A 0
C521 NAND_u1/B S1 0.001f
C522 NAND_u1/B F0 0.3283f
C523 NAND_u1/B NAND_u1/a_512_n286# 0
C524 NAND_u1/B OR_p1/B 0.00444f
C525 NAND_u1/B NAND_u1/A 0.0732f
C526 NAND_u1/B VDD 0.0197f
C527 NAND_a2_0/a_512_n286# S1 0
C528 NAND_a2_0/a_512_n286# S2 0.00231f
C529 S1 NAND_u0/B 0
C530 S1 A2 0.04681f
C531 S1 XOR_h0/Y 0.00697f
C532 S1 XOR_h1/Y 0.0155f
C533 S1 XOR_f0/a_1009_n395# 0.01304f
C534 S1 XOR_f0/a_1155_195# 0.00168f
C535 S1 XOR_f0/a_1463_195# 0.00813f
C536 S1 XOR_f0/a_1609_n395# 0
C537 S1 OR_k0/Y 0.0089f
C538 S1 F0 0.65287f
C539 S1 M 0.04535f
C540 S1 XOR_f1/a_1009_n395# 0.01208f
C541 S1 XOR_f1/a_1155_195# 0.0023f
C542 S1 XOR_f1/a_1463_195# 0.00425f
C543 S1 XOR_f1/a_1609_n395# 0
C544 S1 XOR_f1/m1_n57_n1110# 0.00759f
C545 S1 XOR_f1/m2_n57_n1110# 0.09171f
C546 S1 F1 0.10109f
C547 S1 OR_k1/Y 0.01591f
C548 S1 F2 0.02561f
C549 S1 S2 0.84839f
C550 S1 NAND_v1/A 0.0406f
C551 S1 OR_cy0/B 0.2083f
C552 S1 NAND_v2/A 0.08732f
C553 S1 OR_cy1/B 0.15192f
C554 S1 NAND_v1/a_512_n286# 0
C555 S1 AND_g1/B 0.00515f
C556 S1 S0 4.90901f
C557 S1 NAND_u0/A 0.15894f
C558 S1 OR_p1/B 0.09082f
C559 S1 NAND_a1_1/a_512_n286# 0
C560 S1 NAND_u1/A 0.31362f
C561 S1 NAND_u2/A 0.00392f
C562 S1 VDD 1.31402f
C563 S1 Cn 0
C564 S1 OR_k0/B 0.7459f
C565 S1 OR_p3/B 0.00544f
C566 S1 NAND_u3/A 0.00474f
C567 S1 OR_cy0/a_505_n286# 0
C568 S1 OR_k1/B 0.04843f
C569 S1 XOR_h0/B 0.09152f
C570 S1 XOR_h2/B 0.00417f
C571 S1 XOR_h1/B 0.00311f
C572 NAND_u0/B S2 0.29049f
C573 NAND_u0/B NAND_u0/a_512_n286# 0
C574 NAND_u0/B OR_p0/B 0.00386f
C575 NAND_u0/B NAND_u0/A 0.03097f
C576 NAND_u0/B VDD 0.01477f
C577 OR_p3/a_505_n286# A3 0.02531f
C578 OR_p3/a_505_n286# OR_p3/Y 0.0018f
C579 OR_p3/a_505_n286# VDD 0
C580 OR_p3/a_505_n286# OR_p3/B 0.01613f
C581 OR_p3/a_651_86# A3 0.00512f
C582 OR_p3/a_651_86# OR_p3/B 0.00221f
C583 A3 OR_p3/Y 0.17266f
C584 A3 OR_p2/Y 0.04524f
C585 A3 F0 0.02819f
C586 A3 F1 0.03672f
C587 A3 F2 0.04417f
C588 A3 S2 0.0147f
C589 A3 NAND_a3_3/a_512_n286# 0.00157f
C590 A3 NAND_v3/A 1.42063f
C591 A3 OR_cy3/B 1.29723f
C592 A3 AND_g3/B 0.02828f
C593 A3 VDD 1.7482f
C594 A3 OR_p3/B 0.21975f
C595 OR_p3/Y OR_p2/Y 0.11159f
C596 OR_p3/Y Cn4 0.95553f
C597 OR_p3/Y F0 0.02888f
C598 OR_p3/Y M 0.09282f
C599 OR_p3/Y XOR_h3/a_1009_n395# 0.0161f
C600 OR_p3/Y XOR_h3/a_1155_195# 0.00567f
C601 OR_p3/Y XOR_h3/a_1463_195# 0.02308f
C602 OR_p3/Y XOR_h3/m1_n57_n1110# 0.00879f
C603 OR_p3/Y XOR_h3/m2_n57_n1110# 0.09375f
C604 OR_p3/Y XOR_h3/Y 1.36412f
C605 OR_p3/Y F1 0.03729f
C606 OR_p3/Y XOR_f3/a_1009_n395# 0.01174f
C607 OR_p3/Y XOR_f3/a_1155_195# 0.00439f
C608 OR_p3/Y XOR_f3/a_1463_195# 0.01596f
C609 OR_p3/Y XOR_f3/m1_n57_n1110# 0.00866f
C610 OR_p3/Y XOR_f3/m2_n57_n1110# 0.1036f
C611 OR_p3/Y F3 0.06821f
C612 OR_p3/Y F2 0.0614f
C613 OR_p3/Y OR_k3/a_505_n286# 0.01146f
C614 OR_p3/Y OR_k3/a_651_86# 0.00403f
C615 OR_p3/Y OR_k3/Y 0.01982f
C616 OR_p3/Y NAND_pg/B 0.2156f
C617 OR_p3/Y P_N 0.04247f
C618 OR_p3/Y AND_q3/a_323_n286# 0.00684f
C619 OR_p3/Y AND_q3/a_469_n286# 0
C620 OR_p3/Y OR_gr2/Y 0.06018f
C621 OR_p3/Y NOR_gg/B 0.07113f
C622 OR_p3/Y NAND_v3/A 0.00255f
C623 OR_p3/Y OR_cy3/B 4.30595f
C624 OR_p3/Y AND_g3/B 0.00238f
C625 OR_p3/Y VDD 2.55881f
C626 OR_p3/Y AND_pp01/a_323_n286# 0.00607f
C627 OR_p3/Y AND_pp01/a_469_n286# 0.00192f
C628 OR_p3/Y NAND_pg/A 0.01094f
C629 OR_p3/Y OR_p3/B 0.0247f
C630 OR_p3/Y OR_k3/B 0.01543f
C631 OR_p3/Y XOR_h0/B 0.03836f
C632 OR_p3/Y OR_cy3/Y 0.00256f
C633 OR_p3/Y XOR_h2/B 1.3565f
C634 OR_p3/Y XOR_h1/B 0.03104f
C635 OR_p3/Y AND_g3/a_323_n286# 0.01236f
C636 OR_p3/Y XOR_h3/B 0.07681f
C637 OR_p2/a_505_n286# A2 0.01146f
C638 OR_p2/a_505_n286# OR_p2/Y 0.03149f
C639 OR_p2/a_505_n286# OR_cy1/B 0.00241f
C640 OR_p2/a_505_n286# OR_p2/B 0.00148f
C641 OR_p2/a_505_n286# VDD 0
C642 OR_p2/a_651_86# A2 0.00403f
C643 OR_p2/a_651_86# OR_p2/Y 0.00525f
C644 A2 OR_p2/Y 0.694f
C645 A2 NAND_u2/B 0.00453f
C646 A2 F0 0.02858f
C647 A2 M 0.0872f
C648 A2 F1 0.0371f
C649 A2 S2 0.05222f
C650 A2 NAND_a3_2/a_512_n286# 0.00157f
C651 A2 NAND_v2/A 1.53804f
C652 A2 OR_cy1/B 0.40697f
C653 A2 S0 0.04643f
C654 A2 NAND_v2/a_512_n286# 0.00132f
C655 A2 AND_g2/B 0.03542f
C656 A2 OR_p2/B 0.02393f
C657 A2 NAND_u2/A 1.36014f
C658 A2 VDD 5.51173f
C659 A2 OR_cy1/a_505_n286# 0
C660 A2 OR_k2/B 0.04443f
C661 A2 XOR_h0/B 0.03798f
C662 A2 XOR_h2/B 0.37743f
C663 A2 XOR_h1/B 3.62074f
C664 OR_p2/Y NAND_u2/B 0.00467f
C665 OR_p2/Y Cn4 0.10015f
C666 OR_p2/Y XOR_h2/a_1009_n395# 0.01404f
C667 OR_p2/Y XOR_h2/a_1155_195# 0.00439f
C668 OR_p2/Y XOR_h2/a_1463_195# 0.01994f
C669 OR_p2/Y XOR_h2/m1_n57_n1110# 0.00751f
C670 OR_p2/Y XOR_h2/m2_n57_n1110# 0.10851f
C671 OR_p2/Y XOR_h2/Y 1.2921f
C672 OR_p2/Y F0 0.02858f
C673 OR_p2/Y M 0.61745f
C674 OR_p2/Y XOR_h3/a_1009_n395# 0.00362f
C675 OR_p2/Y XOR_h3/a_1463_195# 0.00346f
C676 OR_p2/Y XOR_h3/a_1609_n395# 0
C677 OR_p2/Y XOR_h3/Y 0.02593f
C678 OR_p2/Y F1 0.0371f
C679 OR_p2/Y XOR_f2/a_1009_n395# 0.00314f
C680 OR_p2/Y XOR_f2/a_1155_195# 0
C681 OR_p2/Y XOR_f2/a_1463_195# 0.00405f
C682 OR_p2/Y XOR_f2/m1_n57_n1110# 0.00831f
C683 OR_p2/Y XOR_f2/m2_n57_n1110# 0.09506f
C684 OR_p2/Y F2 0.16405f
C685 OR_p2/Y OR_k2/a_505_n286# 0
C686 OR_p2/Y OR_k2/Y 0.00337f
C687 OR_p2/Y NAND_pg/B 0.10285f
C688 OR_p2/Y P_N 0.04772f
C689 OR_p2/Y S2 0.0352f
C690 OR_p2/Y NOR_gg/B 0.50096f
C691 OR_p2/Y OR_gr1/Y 0.02034f
C692 OR_p2/Y NAND_v2/A 0.00296f
C693 OR_p2/Y OR_cy1/B 0.00275f
C694 OR_p2/Y NAND_v3/A 0.00288f
C695 OR_p2/Y AND_pc2/a_323_n286# 0.00258f
C696 OR_p2/Y OR_cy2/B 0.20187f
C697 OR_p2/Y OR_cy3/B 0.10149f
C698 OR_p2/Y NAND_v3/a_512_n286# 0.0011f
C699 OR_p2/Y AND_g3/B 0.0731f
C700 OR_p2/Y NAND_u2/a_512_n286# 0.00104f
C701 OR_p2/Y OR_p2/B 0.20773f
C702 OR_p2/Y NAND_u2/A 0.00474f
C703 OR_p2/Y VDD 6.1986f
C704 OR_p2/Y AND_pp23/a_323_n286# 0.00745f
C705 OR_p2/Y AND_pp23/a_469_n286# 0
C706 OR_p2/Y NAND_pg/A 0.32251f
C707 OR_p2/Y OR_p3/B 0.18063f
C708 OR_p2/Y OR_gr1/a_505_n286# 0.0205f
C709 OR_p2/Y OR_gr1/a_651_86# 0.00559f
C710 OR_p2/Y OR_gr1/B 0.0548f
C711 OR_p2/Y OR_k2/B 0.00546f
C712 OR_p2/Y OR_cy2/a_505_n286# 0.00259f
C713 OR_p2/Y OR_cy2/a_651_86# 0
C714 OR_p2/Y OR_k3/B 0.05213f
C715 OR_p2/Y XOR_h0/B 0.225f
C716 OR_p2/Y XOR_h2/B 2.22362f
C717 OR_p2/Y XOR_h1/B 0.10079f
C718 OR_p2/Y XOR_h3/B 0.86293f
C719 NAND_a2_2/a_512_n286# OR_cy1/B 0
C720 NAND_u2/B OR_cy1/B 0.22274f
C721 NAND_u2/B NAND_u2/a_512_n286# 0
C722 NAND_u2/B OR_p2/B 0.004f
C723 NAND_u2/B NAND_u2/A 0.02733f
C724 NAND_u2/B VDD 0.01763f
C725 NAND_u2/B XOR_h0/B 0.00173f
C726 NAND_u2/B XOR_h1/B 0.02526f
C727 XOR_h0/a_1009_n395# XOR_h0/Y 0
C728 XOR_h0/a_1009_n395# M 0.02056f
C729 XOR_h0/a_1009_n395# S2 0.00218f
C730 XOR_h0/a_1009_n395# VDD 0
C731 XOR_h0/a_1009_n395# XOR_h0/B 0.01184f
C732 XOR_h0/a_1155_195# M 0.00568f
C733 XOR_h0/a_1155_195# S2 0
C734 XOR_h0/a_1463_195# M 0.03054f
C735 XOR_h0/a_1609_n395# XOR_h0/B 0.00209f
C736 XOR_h0/m1_n57_n1110# M 0.00849f
C737 XOR_h0/m1_n57_n1110# S2 0.00375f
C738 XOR_h0/m1_n57_n1110# VDD 0.01507f
C739 XOR_h0/m1_n57_n1110# XOR_h0/B 0.00751f
C740 XOR_h0/m2_n57_n1110# M 0.08677f
C741 XOR_h0/m2_n57_n1110# S2 0.03809f
C742 XOR_h0/m2_n57_n1110# VDD 0.03111f
C743 XOR_h0/m2_n57_n1110# XOR_h0/B 0.1085f
C744 XOR_h0/Y XOR_f0/m1_n57_n1110# 0
C745 XOR_h0/Y XOR_f0/m2_n57_n1110# 0.00459f
C746 XOR_h0/Y OR_k0/Y 0.01019f
C747 XOR_h0/Y F0 0.05019f
C748 XOR_h0/Y OR_k0/a_505_n286# 0.00878f
C749 XOR_h0/Y OR_k0/a_651_86# 0.00163f
C750 XOR_h0/Y M 0.3618f
C751 XOR_h0/Y S0 0.03851f
C752 XOR_h0/Y VDD 0.33197f
C753 XOR_h0/Y OR_k0/B 0.00561f
C754 XOR_h0/Y XOR_h0/B 1.44883f
C755 NAND_a2_3/a_512_n286# F2 0.0034f
C756 NAND_a2_3/a_512_n286# OR_p3/B 0
C757 NAND_u3/B F2 0.30906f
C758 NAND_u3/B VDD 0.01856f
C759 NAND_u3/B OR_p3/B 0.22097f
C760 NAND_u3/B NAND_u3/A 0.03199f
C761 NAND_u3/B XOR_h2/B 0.16772f
C762 XOR_h1/a_1009_n395# XOR_h1/Y 0
C763 XOR_h1/a_1009_n395# M 0.00479f
C764 XOR_h1/a_1009_n395# F1 0.04419f
C765 XOR_h1/a_1009_n395# S2 0.00157f
C766 XOR_h1/a_1009_n395# OR_p1/B 0.00108f
C767 XOR_h1/a_1009_n395# VDD 0
C768 XOR_h1/a_1009_n395# OR_k1/B 0.00154f
C769 XOR_h1/a_1155_195# M 0
C770 XOR_h1/a_1155_195# F1 0.00291f
C771 XOR_h1/a_1463_195# M 0.00481f
C772 XOR_h1/a_1463_195# F1 0.02857f
C773 XOR_h1/a_1463_195# S2 0
C774 XOR_h1/a_1609_n395# F1 0.00192f
C775 XOR_h1/m1_n57_n1110# M 0.00884f
C776 XOR_h1/m1_n57_n1110# F1 0.00822f
C777 XOR_h1/m1_n57_n1110# OR_cy1/B 0
C778 XOR_h1/m1_n57_n1110# OR_p1/B 0.00831f
C779 XOR_h1/m1_n57_n1110# VDD 0.00839f
C780 XOR_h1/m1_n57_n1110# OR_k1/B 0
C781 XOR_h1/m1_n57_n1110# XOR_h0/B 0.00157f
C782 XOR_h1/m1_n57_n1110# XOR_h1/B 0.00448f
C783 XOR_h1/m2_n57_n1110# M 0.08783f
C784 XOR_h1/m2_n57_n1110# F1 0.09238f
C785 XOR_h1/m2_n57_n1110# OR_cy1/B 0
C786 XOR_h1/m2_n57_n1110# OR_p1/B 0.09506f
C787 XOR_h1/m2_n57_n1110# VDD 0.02337f
C788 XOR_h1/m2_n57_n1110# OR_k1/B 0.01232f
C789 XOR_h1/m2_n57_n1110# XOR_h0/B 0.00421f
C790 XOR_h1/m2_n57_n1110# XOR_h1/B 0.01929f
C791 XOR_h1/Y M 0.11427f
C792 XOR_h1/Y XOR_f1/m1_n57_n1110# 0
C793 XOR_h1/Y XOR_f1/m2_n57_n1110# 0.00407f
C794 XOR_h1/Y F1 0.37545f
C795 XOR_h1/Y OR_k1/a_505_n286# 0.00414f
C796 XOR_h1/Y OR_k1/Y 0.01013f
C797 XOR_h1/Y S2 0.1235f
C798 XOR_h1/Y S0 0.10982f
C799 XOR_h1/Y OR_p1/B 0.00263f
C800 XOR_h1/Y VDD 0.74781f
C801 XOR_h1/Y OR_k1/B 0.01329f
C802 Cn4 F0 0.03532f
C803 Cn4 F1 0.05195f
C804 Cn4 F3 0.04253f
C805 Cn4 F2 0.12385f
C806 Cn4 NAND_pg/a_512_n286# 0.00231f
C807 Cn4 NAND_pg/B 0.20772f
C808 Cn4 P_N 6.6102f
C809 Cn4 AND_q1/a_323_n286# 0.01065f
C810 Cn4 AND_q1/a_469_n286# 0.00231f
C811 Cn4 AND_q3/a_323_n286# 0.00657f
C812 Cn4 AND_q3/a_469_n286# 0.00112f
C813 Cn4 OR_gr2/Y 0.17497f
C814 Cn4 NOR_gg/B 1.81552f
C815 Cn4 AND_q2/a_323_n286# 0.00657f
C816 Cn4 AND_q2/a_469_n286# 0.00112f
C817 Cn4 OR_gr1/Y 0.18161f
C818 Cn4 OR_cy3/B 0.07175f
C819 Cn4 VDD 0.08483f
C820 Cn4 AND_pp23/a_323_n286# 0.01069f
C821 Cn4 AND_pp23/a_469_n286# 0.00231f
C822 Cn4 AND_pp01/a_323_n286# 0.03962f
C823 Cn4 AND_pp01/a_469_n286# 0.00293f
C824 Cn4 NAND_pg/A 0.71795f
C825 Cn4 OR_gr1/a_505_n286# 0.00834f
C826 Cn4 OR_gr1/B 0.18596f
C827 Cn4 OR_gr2/a_505_n286# 0.00834f
C828 Cn4 OR_gr2/B 0.18427f
C829 Cn4 XOR_h0/B 0.03947f
C830 Cn4 OR_cy3/Y 0.00127f
C831 Cn4 XOR_h2/B 0.03425f
C832 Cn4 XOR_h1/B 0.04504f
C833 Cn4 XOR_h3/B 0.05472f
C834 XOR_h2/a_1009_n395# XOR_h2/Y 0
C835 XOR_h2/a_1009_n395# S2 0.0024f
C836 XOR_h2/a_1009_n395# VDD 0
C837 XOR_h2/a_1009_n395# OR_p3/B 0.00208f
C838 XOR_h2/a_1009_n395# XOR_h2/B 0.01184f
C839 XOR_h2/a_1155_195# OR_p3/B 0.00127f
C840 XOR_h2/a_1463_195# S2 0
C841 XOR_h2/a_1463_195# OR_p3/B 0.00601f
C842 XOR_h2/a_1609_n395# S2 0
C843 XOR_h2/a_1609_n395# XOR_h2/B 0.00209f
C844 XOR_h2/m1_n57_n1110# VDD 0.01491f
C845 XOR_h2/m1_n57_n1110# XOR_h2/B 0.00751f
C846 XOR_h2/m2_n57_n1110# VDD 0.03409f
C847 XOR_h2/m2_n57_n1110# XOR_h2/B 0.10851f
C848 XOR_h2/Y F0 0.02348f
C849 XOR_h2/Y M 0.36019f
C850 XOR_h2/Y F1 0.03195f
C851 XOR_h2/Y XOR_f2/m1_n57_n1110# 0
C852 XOR_h2/Y XOR_f2/m2_n57_n1110# 0.00459f
C853 XOR_h2/Y F2 0.01257f
C854 XOR_h2/Y OR_k2/a_505_n286# 0.00801f
C855 XOR_h2/Y OR_k2/a_651_86# 0.00109f
C856 XOR_h2/Y OR_k2/Y 0.00994f
C857 XOR_h2/Y S2 0.00703f
C858 XOR_h2/Y VDD 0.32743f
C859 XOR_h2/Y OR_p3/B 0.31718f
C860 XOR_h2/Y OR_k2/B 0.04031f
C861 XOR_h2/Y XOR_h2/B 1.39384f
C862 XOR_f0/a_1009_n395# F0 0.04141f
C863 XOR_f0/a_1009_n395# S0 0.00391f
C864 XOR_f0/a_1009_n395# VDD 0
C865 XOR_f0/a_1009_n395# OR_k0/B 0.00154f
C866 XOR_f0/a_1009_n395# XOR_h0/B 0.0161f
C867 XOR_f0/a_1155_195# F0 0.00291f
C868 XOR_f0/a_1155_195# XOR_h0/B 0.00567f
C869 XOR_f0/a_1463_195# F0 0.02857f
C870 XOR_f0/a_1463_195# XOR_h0/B 0.02308f
C871 XOR_f0/a_1609_n395# F0 0
C872 XOR_f0/a_1609_n395# S0 0
C873 XOR_f0/m1_n57_n1110# OR_k0/Y 0.00329f
C874 XOR_f0/m1_n57_n1110# F0 0.00822f
C875 XOR_f0/m1_n57_n1110# S0 0.00838f
C876 XOR_f0/m1_n57_n1110# OR_p1/B 0
C877 XOR_f0/m1_n57_n1110# VDD 0.01371f
C878 XOR_f0/m1_n57_n1110# OR_k0/B 0.00879f
C879 XOR_f0/m1_n57_n1110# XOR_h0/B 0.00838f
C880 XOR_f0/m2_n57_n1110# OR_k0/Y 0.00957f
C881 XOR_f0/m2_n57_n1110# F0 0.08986f
C882 XOR_f0/m2_n57_n1110# S0 0.06496f
C883 XOR_f0/m2_n57_n1110# OR_p1/B 0
C884 XOR_f0/m2_n57_n1110# VDD 0.02728f
C885 XOR_f0/m2_n57_n1110# OR_k0/B 0.08748f
C886 XOR_f0/m2_n57_n1110# XOR_h0/B 0.08877f
C887 OR_k0/Y F0 0.06893f
C888 OR_k0/Y OR_k0/a_505_n286# 0
C889 OR_k0/Y S0 0.33034f
C890 OR_k0/Y VDD 0.00776f
C891 OR_k0/Y OR_k0/B 0.30516f
C892 OR_k0/Y XOR_h0/B 0.03202f
C893 F0 OR_k0/a_505_n286# 0
C894 F0 OR_k0/a_651_86# 0
C895 F0 M 0.02883f
C896 F0 F1 5.91952f
C897 F0 F3 0.01869f
C898 F0 F2 0.05342f
C899 F0 OR_k2/a_505_n286# 0
C900 F0 OR_k2/Y 0.0048f
C901 F0 S2 0.05069f
C902 F0 NAND_v1/A 0.03413f
C903 F0 AND_pc0/a_323_n286# 0.05044f
C904 F0 AND_pc0/a_469_n286# 0.00259f
C905 F0 OR_cy0/B 0.19237f
C906 F0 NOR_gg/B 0.0324f
C907 F0 OR_cy1/B 0.0291f
C908 F0 NAND_v3/A 0.04123f
C909 F0 S0 1.36321f
C910 F0 OR_cy3/B 1.00713f
C911 F0 NAND_u1/a_512_n286# 0.0034f
C912 F0 OR_p1/B 0.24412f
C913 F0 NAND_a1_1/a_512_n286# 0.0034f
C914 F0 NAND_u1/A 0.72638f
C915 F0 NAND_u2/A 0
C916 F0 VDD 2.57134f
C917 F0 OR_k0/B 0.01176f
C918 F0 AND_pp01/a_323_n286# 0
C919 F0 OR_p3/B 0.0297f
C920 F0 G_N 0.41166f
C921 F0 OR_cy0/a_505_n286# 0.03636f
C922 F0 OR_cy0/a_651_86# 0.00386f
C923 F0 OR_k1/B 0.08887f
C924 F0 OR_k2/B 0.03537f
C925 F0 XOR_h0/B 1.89963f
C926 F0 XOR_h2/B 0.0232f
C927 F0 XOR_h1/B 0.0335f
C928 F0 XOR_h3/B 0.05269f
C929 OR_k0/a_505_n286# M 0
C930 OR_k0/a_505_n286# S0 0.00958f
C931 OR_k0/a_505_n286# VDD 0
C932 OR_k0/a_505_n286# OR_k0/B 0
C933 OR_k0/a_505_n286# XOR_h0/B 0.02657f
C934 OR_k0/a_651_86# M 0
C935 OR_k0/a_651_86# S0 0.00185f
C936 OR_k0/a_651_86# XOR_h0/B 0.00515f
C937 M XOR_h3/Y 0.3714f
C938 M F1 0.03943f
C939 M F2 0.0498f
C940 M OR_k2/a_505_n286# 0.00175f
C941 M OR_k3/a_505_n286# 0
C942 M S2 0.85219f
C943 M NAND_a3_1/a_512_n286# 0.00165f
C944 M NAND_v1/A 1.21916f
C945 M NAND_a3_2/a_512_n286# 0.00123f
C946 M NAND_v2/A 0.00962f
C947 M OR_cy1/B 0.09994f
C948 M AND_g1/B 0.00421f
C949 M S0 0.48386f
C950 M OR_cy3/B 0.04297f
C951 M OR_p1/B 0.0446f
C952 M VDD 5.28562f
C953 M OR_k0/B 0.01471f
C954 M OR_p3/B 0.07315f
C955 M OR_k1/B 0.0115f
C956 M OR_k2/B 0.09375f
C957 M OR_k3/B 0.09247f
C958 M XOR_h0/B 0.33067f
C959 M XOR_h2/B 0.54647f
C960 M AND_g1/a_323_n286# -0
C961 M XOR_h1/B 0.08948f
C962 XOR_h3/a_1009_n395# XOR_h3/Y 0
C963 XOR_h3/a_1009_n395# OR_cy3/B 0.04419f
C964 XOR_h3/a_1009_n395# VDD 0
C965 XOR_h3/a_1009_n395# OR_k3/B 0.0186f
C966 XOR_h3/a_1155_195# OR_cy3/B 0.00291f
C967 XOR_h3/a_1463_195# OR_cy3/B 0.02857f
C968 XOR_h3/a_1463_195# OR_k3/B 0.00147f
C969 XOR_h3/a_1609_n395# OR_cy3/B 0.00192f
C970 XOR_h3/a_1609_n395# OR_k3/B 0.00209f
C971 XOR_h3/m1_n57_n1110# OR_cy3/B 0.00822f
C972 XOR_h3/m1_n57_n1110# VDD 0.00838f
C973 XOR_h3/m1_n57_n1110# OR_k3/B 0
C974 XOR_h3/m1_n57_n1110# XOR_h0/B 0.00168f
C975 XOR_h3/m1_n57_n1110# XOR_h1/B 0.00204f
C976 XOR_h3/m1_n57_n1110# XOR_h3/B 0.00485f
C977 XOR_h3/m2_n57_n1110# OR_cy3/B 0.09634f
C978 XOR_h3/m2_n57_n1110# VDD 0.02126f
C979 XOR_h3/m2_n57_n1110# OR_k3/B 0.01367f
C980 XOR_h3/m2_n57_n1110# XOR_h0/B 0.00205f
C981 XOR_h3/m2_n57_n1110# XOR_h1/B 0.00597f
C982 XOR_h3/m2_n57_n1110# XOR_h3/B 0.02319f
C983 XOR_h3/Y XOR_f3/m1_n57_n1110# 0
C984 XOR_h3/Y XOR_f3/m2_n57_n1110# 0.00407f
C985 XOR_h3/Y OR_k3/a_505_n286# 0.00414f
C986 XOR_h3/Y OR_k3/Y 0.01013f
C987 XOR_h3/Y OR_cy3/B 0.36892f
C988 XOR_h3/Y VDD 0.61141f
C989 XOR_h3/Y OR_k3/B 0.1074f
C990 XOR_f1/a_1009_n395# F1 0.04704f
C991 XOR_f1/a_1009_n395# OR_p1/B 0.00108f
C992 XOR_f1/a_1009_n395# VDD 0
C993 XOR_f1/a_1009_n395# OR_k1/B 0.0186f
C994 XOR_f1/a_1155_195# F1 0.00441f
C995 XOR_f1/a_1463_195# F1 0.03298f
C996 XOR_f1/a_1463_195# OR_k1/B 0.00147f
C997 XOR_f1/a_1609_n395# F1 0.00192f
C998 XOR_f1/a_1609_n395# OR_k1/B 0.00209f
C999 XOR_f1/m1_n57_n1110# F1 0.00822f
C1000 XOR_f1/m1_n57_n1110# OR_k1/Y 0.00327f
C1001 XOR_f1/m1_n57_n1110# OR_p1/B 0.00831f
C1002 XOR_f1/m1_n57_n1110# VDD 0.00839f
C1003 XOR_f1/m1_n57_n1110# OR_k1/B 0.00866f
C1004 XOR_f1/m2_n57_n1110# F1 0.09893f
C1005 XOR_f1/m2_n57_n1110# OR_k1/Y 0.00725f
C1006 XOR_f1/m2_n57_n1110# OR_p1/B 0.08302f
C1007 XOR_f1/m2_n57_n1110# VDD 0.02337f
C1008 XOR_f1/m2_n57_n1110# OR_k1/B 0.08902f
C1009 F1 OR_k1/a_505_n286# 0.03547f
C1010 F1 OR_k1/a_651_86# 0.00525f
C1011 F1 OR_k1/Y 0.10412f
C1012 F1 F3 0.0204f
C1013 F1 OR_k2/a_505_n286# 0.00749f
C1014 F1 OR_k2/a_651_86# 0.00109f
C1015 F1 OR_k2/Y 0.01335f
C1016 F1 S2 0.04185f
C1017 F1 NAND_v1/A 0.35163f
C1018 F1 NOR_gg/B 0.08493f
C1019 F1 AND_pc1/a_323_n286# 0.05139f
C1020 F1 AND_pc1/a_469_n286# 0.0026f
C1021 F1 OR_cy1/B 0.1786f
C1022 F1 NAND_v3/A 0.05392f
C1023 F1 NAND_v1/a_512_n286# 0.00209f
C1024 F1 AND_g1/B 0.21956f
C1025 F1 S0 1.0553f
C1026 F1 OR_cy3/B 0.03855f
C1027 F1 OR_p1/B 0.30043f
C1028 F1 NAND_u2/A 0
C1029 F1 VDD 2.51133f
C1030 F1 AND_pp01/a_323_n286# 0
C1031 F1 OR_p3/B 0.03822f
C1032 F1 G_N 0.37159f
C1033 F1 OR_k1/B 0.71715f
C1034 F1 OR_k2/B 0.04694f
C1035 F1 XOR_h0/B 0.03644f
C1036 F1 XOR_h2/B 0.03172f
C1037 F1 AND_g1/a_323_n286# 0.04209f
C1038 F1 AND_g1/a_469_n286# 0.00209f
C1039 F1 XOR_h1/B 0.2321f
C1040 F1 XOR_h3/B 0.04453f
C1041 OR_k1/a_505_n286# OR_k1/Y 0.00137f
C1042 OR_k1/a_505_n286# S2 0
C1043 OR_k1/a_505_n286# S0 0.01465f
C1044 OR_k1/a_505_n286# OR_p1/B 0
C1045 OR_k1/a_505_n286# VDD 0
C1046 OR_k1/a_505_n286# OR_k1/B 0.01437f
C1047 OR_k1/a_651_86# S0 0.00228f
C1048 OR_k1/a_651_86# OR_k1/B 0
C1049 OR_k1/Y S0 0.00633f
C1050 OR_k1/Y OR_p1/B 0.2444f
C1051 OR_k1/Y VDD 0.00776f
C1052 OR_k1/Y OR_k1/B 0.34556f
C1053 XOR_f3/a_1009_n395# F3 0
C1054 XOR_f3/a_1009_n395# OR_cy3/B 0.04696f
C1055 XOR_f3/a_1009_n395# VDD 0
C1056 XOR_f3/a_1009_n395# OR_k3/B 0.0186f
C1057 XOR_f3/a_1155_195# OR_cy3/B 0.00441f
C1058 XOR_f3/a_1463_195# OR_cy3/B 0.03298f
C1059 XOR_f3/a_1463_195# OR_k3/B 0.00147f
C1060 XOR_f3/a_1609_n395# OR_cy3/B 0.00192f
C1061 XOR_f3/a_1609_n395# OR_k3/B 0.00209f
C1062 XOR_f3/m1_n57_n1110# OR_k3/Y 0.00332f
C1063 XOR_f3/m1_n57_n1110# OR_cy3/B 0.00822f
C1064 XOR_f3/m1_n57_n1110# VDD 0.00838f
C1065 XOR_f3/m1_n57_n1110# OR_k3/B 0.00877f
C1066 XOR_f3/m2_n57_n1110# OR_k3/Y 0.0099f
C1067 XOR_f3/m2_n57_n1110# OR_cy3/B 0.09892f
C1068 XOR_f3/m2_n57_n1110# VDD 0.02336f
C1069 XOR_f3/m2_n57_n1110# OR_k3/B 0.10797f
C1070 F3 F2 0.07245f
C1071 F3 P_N 0.03944f
C1072 F3 OR_gr2/Y 0.16748f
C1073 F3 NOR_gg/B 0.04712f
C1074 F3 AEQB 0.00148f
C1075 F3 AND_pc3/a_323_n286# 0.03845f
C1076 F3 AND_pc3/a_469_n286# 0.0026f
C1077 F3 OR_cy3/B 1.33479f
C1078 F3 VDD 0.58146f
C1079 F3 G_N 3.35548f
C1080 F3 OR_gr2/a_505_n286# 0.00345f
C1081 F3 OR_gr2/a_651_86# 0.00108f
C1082 F3 OR_gr2/B 0.00191f
C1083 F3 OR_k3/B 0.09622f
C1084 F3 XOR_h2/B 0.48415f
C1085 XOR_f2/a_1009_n395# F2 0.04428f
C1086 XOR_f2/a_1009_n395# VDD 0
C1087 XOR_f2/a_1009_n395# OR_p3/B 0.02723f
C1088 XOR_f2/a_1009_n395# OR_k2/B 0.01444f
C1089 XOR_f2/a_1009_n395# XOR_h2/B 0.01242f
C1090 XOR_f2/a_1155_195# F2 0.0022f
C1091 XOR_f2/a_1155_195# OR_p3/B 0.00111f
C1092 XOR_f2/a_1155_195# XOR_h2/B 0.00393f
C1093 XOR_f2/a_1463_195# F2 0.01327f
C1094 XOR_f2/a_1463_195# OR_p3/B 0.02238f
C1095 XOR_f2/a_1463_195# XOR_h2/B 0.01694f
C1096 XOR_f2/a_1609_n395# F2 0.00216f
C1097 XOR_f2/a_1609_n395# OR_k2/B 0.00209f
C1098 XOR_f2/m1_n57_n1110# OR_k2/Y 0.00338f
C1099 XOR_f2/m1_n57_n1110# VDD 0.01328f
C1100 XOR_f2/m1_n57_n1110# OR_p3/B 0.00822f
C1101 XOR_f2/m1_n57_n1110# OR_k2/B 0.0088f
C1102 XOR_f2/m1_n57_n1110# XOR_h2/B 0.00838f
C1103 XOR_f2/m2_n57_n1110# F2 0.00661f
C1104 XOR_f2/m2_n57_n1110# OR_k2/Y 0.01019f
C1105 XOR_f2/m2_n57_n1110# VDD 0.02679f
C1106 XOR_f2/m2_n57_n1110# OR_p3/B 0.08224f
C1107 XOR_f2/m2_n57_n1110# OR_k2/B 0.10812f
C1108 XOR_f2/m2_n57_n1110# XOR_h2/B 0.07717f
C1109 F2 OR_k2/Y 0.00744f
C1110 F2 NOR_gg/B 0.04376f
C1111 F2 NAND_v3/A 0.04089f
C1112 F2 AND_pc2/a_323_n286# 0.0387f
C1113 F2 AND_pc2/a_469_n286# 0.00259f
C1114 F2 OR_cy2/B 0.27392f
C1115 F2 S0 0.02679f
C1116 F2 AND_eq/a_323_n286# 0
C1117 F2 OR_cy3/B 0.05079f
C1118 F2 VDD 1.77095f
C1119 F2 AND_pp23/a_323_n286# 0.00283f
C1120 F2 AND_pp23/a_469_n286# 0
C1121 F2 AND_pp01/a_323_n286# 0
C1122 F2 NAND_pg/A 0.04187f
C1123 F2 NAND_u3/a_512_n286# 0.0034f
C1124 F2 OR_p3/B 5.35045f
C1125 F2 NAND_a1_3/a_512_n286# 0.0034f
C1126 F2 NAND_u3/A 0.41815f
C1127 F2 G_N 0.04346f
C1128 F2 OR_k2/B 0.31712f
C1129 F2 OR_cy2/a_505_n286# 0.03059f
C1130 F2 OR_cy2/a_651_86# 0
C1131 F2 OR_k3/B 0.0838f
C1132 F2 XOR_h0/B 0.04198f
C1133 F2 XOR_h2/B 0.11179f
C1134 F2 XOR_h1/B 0.04202f
C1135 F2 XOR_h3/B 0.04913f
C1136 OR_k2/a_505_n286# OR_k2/Y 0
C1137 OR_k2/a_505_n286# VDD 0
C1138 OR_k2/a_505_n286# OR_p3/B 0.03178f
C1139 OR_k2/a_505_n286# OR_k2/B 0.00908f
C1140 OR_k2/a_505_n286# XOR_h2/B 0.00789f
C1141 OR_k2/a_651_86# OR_p3/B 0.00345f
C1142 OR_k2/a_651_86# OR_k2/B 0
C1143 OR_k2/a_651_86# XOR_h2/B 0.00225f
C1144 OR_k2/Y VDD 0.01016f
C1145 OR_k2/Y OR_p3/B 0.13675f
C1146 OR_k2/Y OR_k2/B 0.32009f
C1147 OR_k2/Y XOR_h2/B 0.01514f
C1148 OR_k3/a_505_n286# OR_k3/Y 0.00137f
C1149 OR_k3/a_505_n286# OR_cy3/B 0.03547f
C1150 OR_k3/a_505_n286# VDD 0
C1151 OR_k3/a_505_n286# OR_k3/B 0.00908f
C1152 OR_k3/a_651_86# OR_cy3/B 0.00525f
C1153 OR_k3/a_651_86# OR_k3/B 0
C1154 OR_k3/Y OR_cy3/B 0.14452f
C1155 OR_k3/Y VDD 0.00776f
C1156 OR_k3/Y OR_k3/B 0.32441f
C1157 NAND_pg/a_512_n286# NAND_pg/B 0
C1158 NAND_pg/a_512_n286# NOR_gg/B 0.00209f
C1159 NAND_pg/B P_N 0.00414f
C1160 NAND_pg/B NOR_gg/B 0.07691f
C1161 NAND_pg/B VDD 0.00756f
C1162 NAND_pg/B AND_pp23/a_323_n286# 0
C1163 NAND_pg/B NAND_pg/A 0.10806f
C1164 NAND_pg/B XOR_h3/B 0.00153f
C1165 P_N AND_q1/a_323_n286# 0.03851f
C1166 P_N AND_q1/a_469_n286# 0.00258f
C1167 P_N AND_q3/a_323_n286# 0.02697f
C1168 P_N AND_q3/a_469_n286# 0.0034f
C1169 P_N OR_gr2/Y 0.11572f
C1170 P_N NOR_gg/B 3.97494f
C1171 P_N AND_q2/a_323_n286# 0.02697f
C1172 P_N AND_q2/a_469_n286# 0.0034f
C1173 P_N OR_gr1/Y 0.12979f
C1174 P_N VDD 0.29211f
C1175 P_N OR_gr1/a_505_n286# 0.03033f
C1176 P_N OR_gr1/a_651_86# 0
C1177 P_N OR_gr1/B 0.1912f
C1178 P_N OR_gr2/a_505_n286# 0.03033f
C1179 P_N OR_gr2/a_651_86# 0
C1180 P_N OR_gr2/B 0.11953f
C1181 P_N XOR_h0/B 0.00507f
C1182 P_N XOR_h2/B 0.03545f
C1183 P_N XOR_h1/B 0.04525f
C1184 P_N XOR_h3/B 0.04038f
C1185 NAND_a3_0/a_512_n286# XOR_h0/B 0.00209f
C1186 S2 NAND_v0/A 0
C1187 S2 NAND_v1/A 0
C1188 S2 OR_cy1/B 0.15013f
C1189 S2 NAND_u0/a_512_n286# 0.00231f
C1190 S2 OR_p0/B 0.39439f
C1191 S2 NAND_a1_0/a_512_n286# 0.00231f
C1192 S2 S0 1.88682f
C1193 S2 NAND_u0/A 0.24401f
C1194 S2 OR_p1/B 1.35524f
C1195 S2 VDD 1.86746f
C1196 S2 Cn 0.14829f
C1197 S2 OR_k0/B 0.14863f
C1198 S2 OR_p3/B 1.0429f
C1199 S2 OR_k1/B 0.04289f
C1200 S2 OR_k2/B 0.44234f
C1201 S2 XOR_h0/B 0.34243f
C1202 S2 XOR_h2/B 0.09683f
C1203 S2 XOR_h1/B 0.04294f
C1204 NAND_v0/A VDD 0.78154f
C1205 NAND_v0/A XOR_h0/B 0.48115f
C1206 AND_q1/a_323_n286# NOR_gg/B 0.02777f
C1207 AND_q1/a_323_n286# VDD 0
C1208 AND_q1/a_323_n286# OR_gr1/B 0
C1209 AND_q1/a_323_n286# XOR_h1/B 0.01254f
C1210 AND_q1/a_323_n286# XOR_h3/B 0.00791f
C1211 AND_q1/a_469_n286# XOR_h3/B 0.00112f
C1212 NAND_v1/A S0 0.06148f
C1213 NAND_v1/A OR_p1/B 0.00423f
C1214 NAND_v1/A VDD 0.36312f
C1215 AND_pc0/a_323_n286# OR_cy0/B 0
C1216 AND_pc0/a_323_n286# S0 0.00217f
C1217 AND_pc0/a_323_n286# VDD 0
C1218 AND_pc0/a_323_n286# XOR_h0/B 0.02255f
C1219 OR_cy0/B S0 0.32639f
C1220 OR_cy0/B VDD 0.00637f
C1221 OR_cy0/B OR_k0/B 0
C1222 OR_cy0/B OR_cy0/a_505_n286# 0
C1223 OR_cy0/B OR_k1/B 0
C1224 OR_cy0/B XOR_h0/B 0.03896f
C1225 AND_q3/a_323_n286# OR_gr2/Y 0.00278f
C1226 AND_q3/a_323_n286# NOR_gg/B 0.04011f
C1227 AND_q3/a_323_n286# VDD 0.00377f
C1228 AND_q3/a_323_n286# XOR_h2/B 0
C1229 AND_q3/a_469_n286# NOR_gg/B 0
C1230 OR_gr2/Y NOR_gg/B 0.09007f
C1231 OR_gr2/Y VDD 0.00802f
C1232 OR_gr2/Y OR_gr2/a_505_n286# 0
C1233 OR_gr2/Y OR_gr2/B 0
C1234 OR_gr2/Y XOR_h2/B 0.19314f
C1235 NOR_gg/B AND_q2/a_323_n286# 0.03895f
C1236 NOR_gg/B AND_q2/a_469_n286# 0
C1237 NOR_gg/B OR_gr1/Y 0.09582f
C1238 NOR_gg/B OR_cy3/B 0.26752f
C1239 NOR_gg/B VDD 3.05578f
C1240 NOR_gg/B AND_pp23/a_323_n286# 0.0265f
C1241 NOR_gg/B AND_pp01/a_323_n286# 0.0265f
C1242 NOR_gg/B NAND_pg/A 1.14496f
C1243 NOR_gg/B NOR_gg/a_657_86# 0.00238f
C1244 NOR_gg/B G_N 0.07865f
C1245 NOR_gg/B OR_gr1/a_505_n286# 0.03121f
C1246 NOR_gg/B OR_gr1/a_651_86# 0.00563f
C1247 NOR_gg/B OR_gr1/B 0.07038f
C1248 NOR_gg/B OR_gr2/a_505_n286# 0.03121f
C1249 NOR_gg/B OR_gr2/a_651_86# 0.00563f
C1250 NOR_gg/B OR_gr2/B 0.08527f
C1251 NOR_gg/B XOR_h0/B 0.00546f
C1252 NOR_gg/B OR_cy3/Y 0.02115f
C1253 NOR_gg/B XOR_h2/B 0.53436f
C1254 NOR_gg/B XOR_h1/B 0.49059f
C1255 NOR_gg/B XOR_h3/B 0.66863f
C1256 AND_q2/a_323_n286# OR_gr1/Y 0.00423f
C1257 AND_q2/a_323_n286# VDD 0.00377f
C1258 AND_q2/a_323_n286# OR_gr2/B 0.00239f
C1259 AND_q2/a_469_n286# OR_gr1/Y 0
C1260 AND_q2/a_469_n286# OR_gr2/B 0
C1261 OR_gr1/Y VDD 0.00893f
C1262 OR_gr1/Y OR_gr1/a_505_n286# 0
C1263 OR_gr1/Y OR_gr1/B 0
C1264 OR_gr1/Y OR_gr2/B 0.00108f
C1265 NAND_a3_2/a_512_n286# OR_cy1/B 0.00166f
C1266 NAND_a3_2/a_512_n286# S0 0.00154f
C1267 NAND_v2/A OR_cy1/B 0.08101f
C1268 NAND_v2/A S0 0.03028f
C1269 NAND_v2/A VDD 0.76879f
C1270 NAND_v2/A XOR_h2/B 0.0039f
C1271 AND_pc1/a_323_n286# OR_cy1/B 0.00258f
C1272 AND_pc1/a_323_n286# OR_p1/B 0.00351f
C1273 AND_pc1/a_323_n286# VDD 0.00512f
C1274 AND_pc1/a_469_n286# OR_p1/B 0.00166f
C1275 OR_cy1/B S0 0.39109f
C1276 OR_cy1/B NAND_v2/a_512_n286# 0.00166f
C1277 OR_cy1/B AND_g2/B 0.23611f
C1278 OR_cy1/B OR_p1/B 0.00423f
C1279 OR_cy1/B NAND_u2/a_512_n286# 0
C1280 OR_cy1/B OR_p2/B 0.1741f
C1281 OR_cy1/B NAND_a1_2/a_512_n286# 0
C1282 OR_cy1/B NAND_u2/A 0.00648f
C1283 OR_cy1/B VDD 0.29116f
C1284 OR_cy1/B OR_k1/B 0
C1285 OR_cy1/B OR_cy1/a_505_n286# 0.00464f
C1286 OR_cy1/B OR_k2/B 0.0036f
C1287 OR_cy1/B XOR_h0/B 0.04285f
C1288 OR_cy1/B XOR_h2/B 0.14637f
C1289 OR_cy1/B XOR_h1/B 0.05175f
C1290 NAND_v3/A OR_cy3/B 0.24277f
C1291 NAND_v3/A VDD 0.37008f
C1292 AND_pc2/a_323_n286# OR_cy2/B 0
C1293 AND_pc2/a_323_n286# VDD 0
C1294 AND_pc2/a_323_n286# OR_p3/B 0.02015f
C1295 AND_pc2/a_323_n286# XOR_h2/B 0.01095f
C1296 OR_cy2/B VDD 0.00637f
C1297 OR_cy2/B OR_p3/B 0.06408f
C1298 OR_cy2/B OR_k2/B 0
C1299 OR_cy2/B OR_cy2/a_505_n286# 0
C1300 OR_cy2/B OR_k3/B 0
C1301 OR_cy2/B XOR_h0/B 0.0084f
C1302 OR_cy2/B XOR_h2/B 0.01926f
C1303 OR_cy2/B XOR_h1/B 0
C1304 AND_g1/B OR_p1/B 0.22212f
C1305 AND_g1/B VDD 0.01727f
C1306 AND_g1/B AND_g1/a_323_n286# 0.00415f
C1307 AND_g1/B AND_g1/a_469_n286# 0
C1308 AND_g1/B XOR_h1/B 0
C1309 NAND_v0/a_512_n286# XOR_h0/B 0.00209f
C1310 AND_g0/B VDD 0.0155f
C1311 AND_g0/B AND_g0/a_323_n286# 0.004f
C1312 AND_g0/B AND_g0/a_469_n286# 0
C1313 AND_g0/B XOR_h0/B 0.26357f
C1314 OR_p0/B VDD 0.00724f
C1315 S0 OR_p1/B 0.07826f
C1316 S0 NAND_a1_1/a_512_n286# 0
C1317 S0 NAND_u1/A 0
C1318 S0 NAND_u2/A -0
C1319 S0 VDD 1.20368f
C1320 S0 Cn 0.00176f
C1321 S0 OR_k0/B 1.90244f
C1322 S0 OR_p3/B 0.0056f
C1323 S0 OR_cy0/a_505_n286# 0.00161f
C1324 S0 OR_k1/B 0.04192f
C1325 S0 XOR_h0/B 0.55426f
C1326 S0 XOR_h2/B 0.00418f
C1327 S0 XOR_h1/B 0.00552f
C1328 NAND_u0/A VDD 0.35658f
C1329 AND_eq/a_323_n286# AEQB 0
C1330 AND_eq/a_323_n286# VDD 0.00726f
C1331 AND_eq/a_323_n286# G_N 0.02836f
C1332 AND_eq/a_469_n286# VDD 0
C1333 AND_eq/a_469_n286# G_N 0.00231f
C1334 AEQB VDD 1.24184f
C1335 AEQB G_N 4.73549f
C1336 AND_pc3/a_323_n286# OR_cy3/B 0.02834f
C1337 AND_pc3/a_323_n286# VDD 0.00377f
C1338 AND_pc3/a_323_n286# XOR_h2/B 0.00752f
C1339 AND_pc3/a_469_n286# XOR_h2/B 0.00108f
C1340 OR_cy3/B NAND_v3/a_512_n286# 0.00209f
C1341 OR_cy3/B AND_g3/B 0.26514f
C1342 OR_cy3/B VDD 2.05316f
C1343 OR_cy3/B OR_k3/B 0.81853f
C1344 OR_cy3/B XOR_h0/B 0.03644f
C1345 OR_cy3/B OR_cy3/a_505_n286# 0.01647f
C1346 OR_cy3/B OR_cy3/a_651_86# 0.00238f
C1347 OR_cy3/B OR_cy3/Y 0.08285f
C1348 OR_cy3/B XOR_h2/B 0.04618f
C1349 OR_cy3/B XOR_h1/B 0.02819f
C1350 OR_cy3/B AND_g3/a_323_n286# 0.04209f
C1351 OR_cy3/B AND_g3/a_469_n286# 0.00209f
C1352 OR_cy3/B XOR_h3/B 0.4563f
C1353 AND_g2/B VDD 0.01833f
C1354 AND_g2/B AND_g2/a_323_n286# 0.00432f
C1355 AND_g2/B AND_g2/a_469_n286# 0
C1356 AND_g2/B XOR_h2/B 0.24215f
C1357 NAND_u1/a_512_n286# VDD 0
C1358 OR_p1/B VDD 0.19241f
C1359 OR_p1/B OR_k1/B 3.67339f
C1360 OR_p1/B XOR_h0/B 0.04913f
C1361 OR_p1/B XOR_h1/B 0.18147f
C1362 NAND_u1/A VDD 0.88616f
C1363 NAND_u1/A XOR_h0/B 0
C1364 AND_g3/B VDD 0.01723f
C1365 AND_g3/B AND_g3/a_323_n286# 0.00415f
C1366 AND_g3/B AND_g3/a_469_n286# 0
C1367 AND_g3/B XOR_h3/B 0
C1368 NAND_u2/a_512_n286# XOR_h0/B 0
C1369 OR_p2/B VDD 0.01038f
C1370 OR_p2/B XOR_h0/B 0.04158f
C1371 OR_p2/B XOR_h1/B 0.14085f
C1372 NAND_a1_2/a_512_n286# XOR_h1/B 0
C1373 NAND_u2/A VDD 0.35108f
C1374 NAND_u2/A XOR_h1/B 1.47039f
C1375 VDD Cn 0.19383f
C1376 VDD OR_k0/B 0.3396f
C1377 VDD AND_pp23/a_323_n286# 0
C1378 VDD AND_pp01/a_323_n286# 0
C1379 VDD NAND_pg/A 0.07808f
C1380 VDD OR_p3/B 2.22358f
C1381 VDD NAND_u3/A 0.77823f
C1382 VDD NOR_gg/a_657_86# 0.00205f
C1383 VDD G_N 0.27638f
C1384 VDD OR_cy0/a_505_n286# 0
C1385 VDD OR_k1/B 0.22317f
C1386 VDD OR_gr1/a_505_n286# 0
C1387 VDD OR_gr1/B 0.00641f
C1388 VDD OR_cy1/a_505_n286# 0
C1389 VDD OR_k2/B 0.19288f
C1390 VDD OR_gr2/a_505_n286# 0
C1391 VDD OR_gr2/B 0.01109f
C1392 VDD OR_cy2/a_505_n286# 0
C1393 VDD OR_k3/B 0.22863f
C1394 VDD AND_g0/a_323_n286# 0.00377f
C1395 VDD XOR_h0/B 4.62288f
C1396 VDD OR_cy3/a_505_n286# 0
C1397 VDD OR_cy3/Y 0.00519f
C1398 VDD AND_g2/a_323_n286# 0.00377f
C1399 VDD XOR_h2/B 4.84711f
C1400 VDD AND_g1/a_323_n286# 0
C1401 VDD XOR_h1/B 2.7499f
C1402 VDD AND_g3/a_323_n286# 0
C1403 VDD XOR_h3/B 4.44576f
C1404 Cn OR_k0/B 0.00185f
C1405 OR_k0/B XOR_h0/B 0.08153f
C1406 AND_pp23/a_323_n286# NAND_pg/A 0.03813f
C1407 AND_pp23/a_323_n286# XOR_h3/B -0
C1408 AND_pp23/a_469_n286# NAND_pg/A 0.00227f
C1409 AND_pp01/a_323_n286# NAND_pg/A 0
C1410 AND_pp01/a_323_n286# XOR_h3/B 0
C1411 NAND_pg/A XOR_h3/B 0.31642f
C1412 NAND_u3/a_512_n286# OR_p3/B 0
C1413 NAND_u3/a_512_n286# XOR_h2/B 0
C1414 OR_p3/B NAND_a1_3/a_512_n286# 0
C1415 OR_p3/B NAND_u3/A 0.48084f
C1416 OR_p3/B OR_k2/B 0.38819f
C1417 OR_p3/B OR_cy2/a_505_n286# 0.02665f
C1418 OR_p3/B OR_cy2/a_651_86# 0.00345f
C1419 OR_p3/B OR_k3/B 0.11331f
C1420 OR_p3/B XOR_h0/B 0.0352f
C1421 OR_p3/B XOR_h2/B 1.60807f
C1422 OR_p3/B XOR_h1/B 0.0352f
C1423 NAND_u3/A XOR_h2/B 1.35808f
C1424 NOR_gg/a_657_86# XOR_h3/B 0.00168f
C1425 G_N XOR_h3/B 0.00553f
C1426 OR_cy0/a_505_n286# OR_k1/B 0.00164f
C1427 OR_cy0/a_505_n286# XOR_h0/B 0.01736f
C1428 OR_cy0/a_651_86# XOR_h0/B 0.00427f
C1429 OR_k1/B XOR_h0/B 0.07848f
C1430 OR_k1/B XOR_h1/B 0.0294f
C1431 OR_gr1/a_505_n286# OR_gr1/B 0
C1432 OR_gr1/B XOR_h0/B 0
C1433 OR_gr1/B XOR_h1/B 0.01537f
C1434 OR_gr1/B XOR_h3/B 0.00274f
C1435 OR_cy1/a_505_n286# OR_k2/B 0.00192f
C1436 OR_cy1/a_505_n286# XOR_h1/B 0.01587f
C1437 OR_cy1/a_651_86# XOR_h1/B 0.00413f
C1438 OR_k2/B XOR_h2/B 0.57014f
C1439 OR_k2/B XOR_h1/B 0.06943f
C1440 OR_gr2/a_505_n286# OR_gr2/B 0
C1441 OR_gr2/a_505_n286# XOR_h2/B 0.00787f
C1442 OR_gr2/a_651_86# XOR_h2/B 0.00317f
C1443 OR_gr2/B XOR_h2/B 0.01262f
C1444 OR_cy2/a_505_n286# OR_k3/B 0.0013f
C1445 OR_cy2/a_505_n286# XOR_h0/B 0.01522f
C1446 OR_cy2/a_505_n286# XOR_h2/B 0.00497f
C1447 OR_cy2/a_505_n286# XOR_h1/B 0.00768f
C1448 OR_cy2/a_651_86# XOR_h0/B 0.00221f
C1449 OR_cy2/a_651_86# XOR_h2/B 0.00167f
C1450 OR_k3/B XOR_h0/B 0
C1451 OR_k3/B XOR_h2/B 0.09116f
C1452 OR_k3/B XOR_h1/B 0.14723f
C1453 OR_k3/B XOR_h3/B 0.03535f
C1454 AND_g0/a_323_n286# XOR_h0/B 0.0432f
C1455 AND_g0/a_469_n286# XOR_h0/B 0.00209f
C1456 XOR_h0/B XOR_h2/B 0.04619f
C1457 XOR_h0/B AND_g1/a_323_n286# 0.00279f
C1458 XOR_h0/B XOR_h1/B 5.03991f
C1459 XOR_h0/B AND_g3/a_323_n286# 0.00279f
C1460 XOR_h0/B XOR_h3/B 0.06899f
C1461 OR_cy3/a_505_n286# OR_cy3/Y 0
C1462 OR_cy3/a_505_n286# XOR_h3/B 0.01831f
C1463 OR_cy3/a_651_86# XOR_h3/B 0.00413f
C1464 OR_cy3/Y XOR_h3/B 0.08195f
C1465 AND_g2/a_323_n286# XOR_h2/B 0.04303f
C1466 AND_g2/a_469_n286# XOR_h2/B 0.00209f
C1467 XOR_h2/B XOR_h1/B 0.04128f
C1468 AND_g1/a_323_n286# XOR_h1/B 0
C1469 XOR_h1/B AND_g3/a_323_n286# 0
C1470 XOR_h1/B XOR_h3/B 1.86376f
C1471 AND_g3/a_323_n286# XOR_h3/B 0
C1472 XOR_h3/B VSS 1.99606f
C1473 AND_g3/a_469_n286# VSS 0
C1474 AND_g3/a_323_n286# VSS 0.00359f
C1475 XOR_h1/B VSS 1.55025f
C1476 AND_g1/a_323_n286# VSS 0
C1477 XOR_h2/B VSS 2.62746f
C1478 AND_g2/a_469_n286# VSS 0
C1479 AND_g2/a_323_n286# VSS 0.00359f
C1480 OR_cy3/Y VSS 0.19481f
C1481 OR_cy3/a_505_n286# VSS 0
C1482 XOR_h0/B VSS 4.25602f
C1483 AND_g0/a_469_n286# VSS 0
C1484 AND_g0/a_323_n286# VSS 0.00359f
C1485 OR_k3/B VSS 3.82193f
C1486 OR_cy2/a_505_n286# VSS 0.00129f
C1487 OR_gr2/B VSS 0.49034f
C1488 OR_gr2/a_505_n286# VSS 0
C1489 OR_k2/B VSS 3.19894f
C1490 OR_cy1/a_505_n286# VSS 0
C1491 OR_gr1/B VSS 0.44413f
C1492 OR_gr1/a_505_n286# VSS 0
C1493 OR_k1/B VSS 1.9775f
C1494 OR_cy0/a_505_n286# VSS 0
C1495 G_N VSS 3.02584f
C1496 NAND_u3/A VSS 0.54958f
C1497 NAND_a1_3/a_512_n286# VSS 0
C1498 OR_p3/B VSS 1.56499f
C1499 NAND_u3/a_512_n286# VSS 0
C1500 NAND_pg/A VSS 0.38711f
C1501 AND_pp01/a_323_n286# VSS 0
C1502 AND_pp23/a_323_n286# VSS 0
C1503 OR_k0/B VSS 2.51937f
C1504 Cn VSS 0.20535f
C1505 VDD VSS 0.11196p
C1506 NAND_u2/A VSS 0.33816f
C1507 OR_p2/B VSS 0.38563f
C1508 AND_g3/B VSS 0.45964f
C1509 NAND_v3/a_512_n286# VSS 0
C1510 NAND_u1/A VSS 0.60068f
C1511 OR_p1/B VSS 8.06551f
C1512 NAND_u1/a_512_n286# VSS 0
C1513 AND_g2/B VSS 0.42677f
C1514 OR_cy3/B VSS 2.28132f
C1515 AND_pc3/a_469_n286# VSS 0
C1516 AND_pc3/a_323_n286# VSS 0.00181f
C1517 AEQB VSS 2.78076f
C1518 AND_eq/a_323_n286# VSS 0
C1519 NAND_u0/A VSS 0.3642f
C1520 S0 VSS 5.01105f
C1521 OR_p0/B VSS 0.4425f
C1522 AND_g0/B VSS 0.51111f
C1523 NAND_v0/a_512_n286# VSS 0
C1524 AND_g1/B VSS 0.38171f
C1525 OR_cy2/B VSS 0.43392f
C1526 AND_pc2/a_469_n286# VSS 0
C1527 AND_pc2/a_323_n286# VSS 0.00181f
C1528 NAND_v3/A VSS 0.42301f
C1529 NAND_a3_3/a_512_n286# VSS 0
C1530 OR_cy1/B VSS 8.16607f
C1531 AND_pc1/a_323_n286# VSS 0
C1532 NAND_v2/A VSS 0.56272f
C1533 OR_gr1/Y VSS 0.48997f
C1534 AND_q2/a_323_n286# VSS 0
C1535 NOR_gg/B VSS 1.80244f
C1536 OR_gr2/Y VSS 0.3378f
C1537 AND_q3/a_323_n286# VSS 0
C1538 OR_cy0/B VSS 0.31522f
C1539 AND_pc0/a_323_n286# VSS 0
C1540 NAND_v1/A VSS 0.31053f
C1541 AND_q1/a_323_n286# VSS 0
C1542 NAND_v0/A VSS 0.483f
C1543 S2 VSS 7.83832f
C1544 P_N VSS 0.92058f
C1545 NAND_pg/B VSS 0.34589f
C1546 OR_k3/Y VSS 0.46613f
C1547 OR_k3/a_505_n286# VSS 0
C1548 OR_k2/Y VSS 0.37228f
C1549 OR_k2/a_505_n286# VSS 0
C1550 F2 VSS 4.07282f
C1551 XOR_f2/m2_n57_n1110# VSS 0.02782f
C1552 XOR_f2/m1_n57_n1110# VSS 0.01241f
C1553 XOR_f2/a_1009_n395# VSS 0
C1554 F3 VSS 6.43717f
C1555 XOR_f3/m2_n57_n1110# VSS 0.02335f
C1556 XOR_f3/m1_n57_n1110# VSS 0.00837f
C1557 XOR_f3/a_1009_n395# VSS 0
C1558 OR_k1/Y VSS 0.33413f
C1559 OR_k1/a_505_n286# VSS 0
C1560 F1 VSS 2.39837f
C1561 XOR_f1/m2_n57_n1110# VSS 0.0277f
C1562 XOR_f1/m1_n57_n1110# VSS 0.01357f
C1563 XOR_f1/a_1009_n395# VSS 0
C1564 XOR_h3/Y VSS 0.43777f
C1565 XOR_h3/m2_n57_n1110# VSS 0.03331f
C1566 XOR_h3/m1_n57_n1110# VSS 0.01355f
C1567 XOR_h3/a_1009_n395# VSS 0
C1568 M VSS 2.68441f
C1569 OR_k0/a_505_n286# VSS 0
C1570 F0 VSS 2.69626f
C1571 OR_k0/Y VSS 0.36037f
C1572 XOR_f0/m2_n57_n1110# VSS 0.0278f
C1573 XOR_f0/m1_n57_n1110# VSS 0.0124f
C1574 XOR_f0/a_1009_n395# VSS 0
C1575 XOR_h2/Y VSS 0.3793f
C1576 XOR_h2/m2_n57_n1110# VSS 0.03262f
C1577 XOR_h2/m1_n57_n1110# VSS 0.0142f
C1578 XOR_h2/a_1009_n395# VSS 0
C1579 Cn4 VSS 3.52028f
C1580 XOR_h1/Y VSS 0.47447f
C1581 XOR_h1/m2_n57_n1110# VSS 0.02127f
C1582 XOR_h1/m1_n57_n1110# VSS 0.00839f
C1583 XOR_h1/a_1009_n395# VSS 0
C1584 NAND_u3/B VSS 0.43039f
C1585 NAND_a2_3/a_512_n286# VSS 0
C1586 XOR_h0/Y VSS 0.38101f
C1587 XOR_h0/m2_n57_n1110# VSS 0.0326f
C1588 XOR_h0/m1_n57_n1110# VSS 0.01418f
C1589 XOR_h0/a_1009_n395# VSS 0
C1590 NAND_u2/B VSS 0.40219f
C1591 OR_p2/Y VSS 2.98381f
C1592 A2 VSS 0.57446f
C1593 OR_p2/a_505_n286# VSS 0
C1594 OR_p3/Y VSS 4.86318f
C1595 A3 VSS 0.70778f
C1596 OR_p3/a_505_n286# VSS 0
C1597 NAND_u0/B VSS 0.47639f
C1598 S1 VSS 10.08235f
C1599 NAND_u1/B VSS 0.50473f
C1600 NAND_a2_1/a_512_n286# VSS 0
C1601 OR_p1/Y VSS 1.97148f
C1602 A1 VSS 0.73322f
C1603 OR_p1/a_505_n286# VSS 0
C1604 NOT_nb3/Y VSS 1.23816f
C1605 B3 VSS 0.85926f
C1606 OR_p0/Y VSS 1.59799f
C1607 A0 VSS 0.46122f
C1608 OR_p0/a_505_n286# VSS 0
C1609 NOT_nb2/Y VSS 0.76078f
C1610 B2 VSS 2.32766f
C1611 NAND_v2/B VSS 0.4683f
C1612 NAND_v3/B VSS 0.43901f
C1613 NAND_a4_3/a_512_n286# VSS 0
C1614 NOT_nb1/Y VSS 2.56405f
C1615 B1 VSS 1.98428f
C1616 NAND_v1/B VSS 0.31767f
C1617 NOT_nb0/Y VSS 0.63348f
C1618 B0 VSS 1.20152f
C1619 NAND_v0/B VSS 0.51522f
C1620 S3 VSS 3.85782f
C1621 NAND_a4_0/a_512_n286# VSS 0
C1622 AND_eq/B VSS 0.3073f
C1623 AND_e23/a_323_n286# VSS 0
C1624 AND_eq/A VSS 0.49096f
C1625 AND_e01/a_323_n286# VSS 0
.ends

XDUT A0 A1 A2 A3 B0 B1 B2 B3 S0 S1 S2 S3 M Cn F0 F1 F2 F3 AEQB P_N G_N Cn4 VDD VSS ALU181
VDD VDD 0 3.3
VSS VSS 0 0
VA0 A0 0 PWL(0 3.3 7e-09 3.3 7.05e-09 0 1.4e-08 0 1.405e-08 0 2.1e-08 0 2.105e-08 0 2.8e-08 0 2.805e-08 0 3.5e-08 0 3.505e-08 3.3 4.2e-08 3.3 4.205e-08 3.3 4.9e-08 3.3 4.905e-08 3.3 5.6e-08 3.3 5.605e-08 3.3 6.3e-08 3.3 6.305e-08 3.3 7e-08 3.3 7.005e-08 0 7.7e-08 0 7.705e-08 0 8.4e-08 0 8.405e-08 0 9.1e-08 0 9.105e-08 0 9.8e-08 0 9.805e-08 3.3 1.05e-07 3.3 1.051e-07 3.3 1.12e-07 3.3 1.121e-07 0 1.19e-07 0 1.19e-07 0 1.26e-07 0 1.26e-07 3.3 1.33e-07 3.3 1.33e-07 3.3 1.4e-07 3.3 1.4e-07 0 1.47e-07 0 1.471e-07 0 1.54e-07 0 1.541e-07 3.3 1.61e-07 3.3 1.611e-07 0 1.68e-07 0 1.68e-07 3.3 1.75e-07 3.3 1.75e-07 3.3 1.82e-07 3.3 1.82e-07 3.3 1.89e-07 3.3 1.89e-07 0 1.96e-07 0 1.961e-07 3.3 2.03e-07 3.3 2.031e-07 3.3 2.1e-07 3.3 2.101e-07 0 2.17e-07 0 2.171e-07 0 2.24e-07 0 2.24e-07 0 2.31e-07 0 2.31e-07 0 2.38e-07 0 2.38e-07 3.3 2.45e-07 3.3 2.45e-07 3.3 2.52e-07 3.3 2.52e-07 3.3 2.59e-07 3.3 2.59e-07 3.3 2.66e-07 3.3 2.66e-07 0 2.73e-07 0 2.73e-07 0 2.8e-07 0 2.8e-07 0 2.87e-07 0 2.871e-07 3.3 2.94e-07 3.3 2.941e-07 3.3 3.01e-07 3.3 3.011e-07 0 3.08e-07 0 3.081e-07 0 3.15e-07 0 3.151e-07 3.3 3.22e-07 3.3 3.221e-07 0 3.29e-07 0 3.29e-07 0 3.36e-07 0 3.36e-07 3.3 3.43e-07 3.3 3.43e-07 0 3.5e-07 0 3.5e-07 3.3 3.57e-07 3.3 3.57e-07 0 3.64e-07 0 3.64e-07 3.3 3.71e-07 3.3 3.71e-07 0 3.78e-07 0 3.78e-07 3.3 3.85e-07 3.3 3.85e-07 0 3.92e-07 0 3.921e-07 0 3.99e-07 0 3.991e-07 0 4.06e-07 0 4.061e-07 0 4.13e-07 0 4.131e-07 0 4.2e-07 0 4.201e-07 0 4.27e-07 0 4.271e-07 3.3 4.34e-07 3.3 4.34e-07 0 4.41e-07 0 4.41e-07 0 4.48e-07 0 4.48e-07 0 4.55e-07 0 4.55e-07 0 4.62e-07 0 4.62e-07 3.3 4.69e-07 3.3 4.69e-07 3.3 4.76e-07 3.3 4.76e-07 0 4.83e-07 0 4.83e-07 0 4.9e-07 0 4.9e-07 3.3 4.97e-07 3.3 4.97e-07 3.3 5.04e-07 3.3 5.04e-07 0 5.11e-07 0 5.11e-07 3.3 5.18e-07 3.3 5.18e-07 0 5.25e-07 0 5.25e-07 0 5.32e-07 0 5.32e-07 3.3 5.39e-07 3.3 5.39e-07 0 5.46e-07 0 5.46e-07 0 5.53e-07 0 5.53e-07 3.3 5.6e-07 3.3 5.6e-07 0 5.67e-07 0 5.671e-07 3.3 5.74e-07 3.3 5.741e-07 0 5.81e-07 0 5.811e-07 0 5.88e-07 0 5.881e-07 3.3 5.95e-07 3.3 5.951e-07 0 6.02e-07 0 6.021e-07 0 6.09e-07 0 6.091e-07 0 6.16e-07 0 6.161e-07 0 6.23e-07 0 6.231e-07 3.3 6.3e-07 3.3 6.301e-07 3.3 6.37e-07 3.3 6.371e-07 0 6.44e-07 0 6.441e-07 3.3 6.51e-07 3.3 6.51e-07 3.3 6.58e-07 3.3 6.58e-07 0 6.65e-07 0 6.65e-07 0 6.72e-07 0 6.72e-07 0 6.79e-07 0 6.79e-07 3.3 6.86e-07 3.3 6.86e-07 0 6.93e-07 0 6.93e-07 3.3 7e-07 3.3 7e-07 0 7.07e-07 0 7.07e-07 3.3 7.14e-07 3.3 7.14e-07 3.3 7.21e-07 3.3 7.21e-07 3.3 7.28e-07 3.3 7.28e-07 0 7.35e-07 0 7.35e-07 3.3 7.42e-07 3.3 7.42e-07 0 7.49e-07 0 7.49e-07 0 7.56e-07 0 7.56e-07 3.3 7.63e-07 3.3 7.63e-07 3.3 7.7e-07 3.3 7.7e-07 0 7.77e-07 0 7.77e-07 0 7.84e-07 0 7.841e-07 3.3 7.91e-07 3.3 7.911e-07 3.3 7.98e-07 3.3 7.981e-07 0 8.05e-07 0 8.051e-07 0 8.12e-07 0 8.121e-07 3.3 8.19e-07 3.3 8.191e-07 0 8.26e-07 0 8.261e-07 3.3 8.33e-07 3.3 8.331e-07 3.3 8.4e-07 3.3 8.401e-07 0 8.47e-07 0 8.471e-07 3.3 8.54e-07 3.3 8.541e-07 3.3 8.61e-07 3.3 8.61e-07 3.3 8.68e-07 3.3 8.68e-07 3.3 8.75e-07 3.3 8.75e-07 0 8.82e-07 0 8.82e-07 0 8.89e-07 0 8.89e-07 3.3 8.96e-07 3.3 8.96e-07 3.3 9.03e-07 3.3 9.03e-07 3.3 9.1e-07 3.3 9.1e-07 0 9.17e-07 0 9.17e-07 3.3 9.24e-07 3.3 9.24e-07 0 9.31e-07 0 9.31e-07 0 9.38e-07 0 9.38e-07 0 9.45e-07 0 9.45e-07 0 9.52e-07 0 9.52e-07 3.3 9.59e-07 3.3 9.59e-07 3.3 9.66e-07 3.3 9.66e-07 3.3 9.73e-07 3.3 9.73e-07 3.3 9.8e-07 3.3 9.8e-07 0 9.87e-07 0 9.87e-07 0 9.94e-07 0 9.94e-07 3.3 1.001e-06 3.3 1.001e-06 0 1.008e-06 0 1.008e-06 3.3 1.015e-06 3.3 1.015e-06 3.3 1.022e-06 3.3 1.022e-06 3.3 1.029e-06 3.3 1.029e-06 0 1.036e-06 0 1.036e-06 0 1.043e-06 0 1.043e-06 0 1.05e-06 0 1.05e-06 3.3 1.057e-06 3.3 1.057e-06 0 1.064e-06 0 1.064e-06 0 1.071e-06 0 1.071e-06 3.3 1.078e-06 3.3 1.078e-06 3.3 1.085e-06 3.3 1.085e-06 3.3 1.092e-06 3.3 1.092e-06 0 1.099e-06 0 1.099e-06 0 1.106e-06 0 1.106e-06 3.3 1.113e-06 3.3 1.113e-06 3.3 1.12e-06 3.3 1.12e-06 3.3 1.127e-06 3.3 1.127e-06 0 1.134e-06 0 1.134e-06 0 1.141e-06 0 1.141e-06 3.3 1.148e-06 3.3 1.148e-06 3.3 1.155e-06 3.3 1.155e-06 0 1.162e-06 0 1.162e-06 0 1.169e-06 0 1.169e-06 0 1.176e-06 0 1.176e-06 3.3 1.183e-06 3.3 1.183e-06 3.3 1.19e-06 3.3 1.19e-06 0 1.197e-06 0 1.197e-06 0 1.204e-06 0 1.204e-06 3.3 1.211e-06 3.3 1.211e-06 3.3 1.218e-06 3.3 1.218e-06 0 1.225e-06 0 1.225e-06 0 1.232e-06 0 1.232e-06 0 1.239e-06 0 1.239e-06 0 1.246e-06 0 1.246e-06 0 1.253e-06 0 1.253e-06 0 1.26e-06 0 1.26e-06 0 1.267e-06 0 1.267e-06 3.3 1.274e-06 3.3 1.274e-06 0 1.281e-06 0 1.281e-06 3.3 1.288e-06 3.3 1.288e-06 0 1.295e-06 0 1.295e-06 0 1.302e-06 0 1.302e-06 3.3 1.309e-06 3.3 1.309e-06 3.3 1.316e-06 3.3 1.316e-06 0 1.323e-06 0 1.323e-06 3.3 1.33e-06 3.3 1.33e-06 3.3 1.337e-06 3.3 1.337e-06 0 1.344e-06 0 1.344e-06 3.3 1.351e-06 3.3 1.351e-06 0 1.358e-06 0 1.358e-06 3.3 1.365e-06 3.3 1.365e-06 0 1.372e-06 0 1.372e-06 0 1.379e-06 0 1.379e-06 0 1.386e-06 0 1.386e-06 3.3 1.393e-06 3.3 1.393e-06 0 1.4e-06 0 1.4e-06 0 1.407e-06 0 1.407e-06 0 1.414e-06 0 1.414e-06 3.3 1.421e-06 3.3 1.421e-06 0 1.428e-06 0 1.428e-06 3.3 1.435e-06 3.3 1.435e-06 0 1.442e-06 0 1.442e-06 0 1.449e-06 0 1.449e-06 3.3 1.456e-06 3.3 1.456e-06 3.3 1.463e-06 3.3 1.463e-06 3.3 1.47e-06 3.3 1.47e-06 3.3 1.477e-06 3.3 1.477e-06 3.3 1.484e-06 3.3 1.484e-06 3.3 1.491e-06 3.3 1.491e-06 0 1.498e-06 0 1.498e-06 3.3 1.505e-06 3.3 1.505e-06 3.3 1.512e-06 3.3 1.512e-06 0 1.519e-06 0 1.519e-06 0 1.526e-06 0 1.526e-06 0 1.533e-06 0 1.533e-06 0 1.54e-06 0 1.54e-06 0 1.547e-06 0 1.547e-06 0 1.554e-06 0 1.554e-06 3.3 1.561e-06 3.3 1.561e-06 3.3 1.568e-06 3.3 1.568e-06 0 1.575e-06 0 1.575e-06 0 1.582e-06 0 1.582e-06 3.3 1.589e-06 3.3 1.589e-06 3.3 1.596e-06 3.3 1.596e-06 3.3 1.603e-06 3.3 1.603e-06 0 1.61e-06 0 1.61e-06 0 1.617e-06 0 1.617e-06 3.3 1.624e-06 3.3 1.624e-06 3.3 1.631e-06 3.3 1.631e-06 0 1.638e-06 0 1.638e-06 0 1.645e-06 0 1.645e-06 3.3 1.652e-06 3.3 1.652e-06 3.3 1.659e-06 3.3 1.659e-06 3.3 1.666e-06 3.3 1.666e-06 3.3 1.673e-06 3.3 1.673e-06 0 1.68e-06 0 1.68e-06 3.3 1.687e-06 3.3 1.687e-06 0 1.694e-06 0 1.694e-06 0 1.701e-06 0 1.701e-06 3.3 1.708e-06 3.3 1.708e-06 3.3 1.715e-06 3.3 1.715e-06 3.3 1.722e-06 3.3 1.722e-06 3.3 1.729e-06 3.3 1.729e-06 0 1.736e-06 0 1.736e-06 0 1.743e-06 0 1.743e-06 3.3 1.75e-06 3.3 1.75e-06 3.3 1.757e-06 3.3 1.757e-06 3.3 1.764e-06 3.3 1.764e-06 0 1.771e-06 0 1.771e-06 3.3 1.778e-06 3.3 1.778e-06 0 1.785e-06 0 1.785e-06 0 1.792e-06 0 1.792e-06 3.3 1.799e-06 3.3 1.799e-06 3.3 1.806e-06 3.3 1.806e-06 3.3 1.813e-06 3.3 1.813e-06 3.3)
VA1 A1 0 PWL(0 3.3 7e-09 3.3 7.05e-09 3.3 1.4e-08 3.3 1.405e-08 3.3 2.1e-08 3.3 2.105e-08 3.3 2.8e-08 3.3 2.805e-08 3.3 3.5e-08 3.3 3.505e-08 3.3 4.2e-08 3.3 4.205e-08 3.3 4.9e-08 3.3 4.905e-08 0 5.6e-08 0 5.605e-08 3.3 6.3e-08 3.3 6.305e-08 0 7e-08 0 7.005e-08 0 7.7e-08 0 7.705e-08 0 8.4e-08 0 8.405e-08 3.3 9.1e-08 3.3 9.105e-08 3.3 9.8e-08 3.3 9.805e-08 3.3 1.05e-07 3.3 1.051e-07 3.3 1.12e-07 3.3 1.121e-07 0 1.19e-07 0 1.19e-07 0 1.26e-07 0 1.26e-07 3.3 1.33e-07 3.3 1.33e-07 3.3 1.4e-07 3.3 1.4e-07 3.3 1.47e-07 3.3 1.471e-07 3.3 1.54e-07 3.3 1.541e-07 0 1.61e-07 0 1.611e-07 3.3 1.68e-07 3.3 1.68e-07 0 1.75e-07 0 1.75e-07 0 1.82e-07 0 1.82e-07 0 1.89e-07 0 1.89e-07 0 1.96e-07 0 1.961e-07 3.3 2.03e-07 3.3 2.031e-07 0 2.1e-07 0 2.101e-07 0 2.17e-07 0 2.171e-07 0 2.24e-07 0 2.24e-07 0 2.31e-07 0 2.31e-07 3.3 2.38e-07 3.3 2.38e-07 0 2.45e-07 0 2.45e-07 0 2.52e-07 0 2.52e-07 0 2.59e-07 0 2.59e-07 3.3 2.66e-07 3.3 2.66e-07 0 2.73e-07 0 2.73e-07 3.3 2.8e-07 3.3 2.8e-07 3.3 2.87e-07 3.3 2.871e-07 0 2.94e-07 0 2.941e-07 0 3.01e-07 0 3.011e-07 3.3 3.08e-07 3.3 3.081e-07 0 3.15e-07 0 3.151e-07 3.3 3.22e-07 3.3 3.221e-07 3.3 3.29e-07 3.3 3.29e-07 3.3 3.36e-07 3.3 3.36e-07 0 3.43e-07 0 3.43e-07 0 3.5e-07 0 3.5e-07 3.3 3.57e-07 3.3 3.57e-07 3.3 3.64e-07 3.3 3.64e-07 3.3 3.71e-07 3.3 3.71e-07 3.3 3.78e-07 3.3 3.78e-07 3.3 3.85e-07 3.3 3.85e-07 0 3.92e-07 0 3.921e-07 0 3.99e-07 0 3.991e-07 0 4.06e-07 0 4.061e-07 3.3 4.13e-07 3.3 4.131e-07 3.3 4.2e-07 3.3 4.201e-07 0 4.27e-07 0 4.271e-07 0 4.34e-07 0 4.34e-07 3.3 4.41e-07 3.3 4.41e-07 0 4.48e-07 0 4.48e-07 0 4.55e-07 0 4.55e-07 0 4.62e-07 0 4.62e-07 0 4.69e-07 0 4.69e-07 0 4.76e-07 0 4.76e-07 3.3 4.83e-07 3.3 4.83e-07 3.3 4.9e-07 3.3 4.9e-07 0 4.97e-07 0 4.97e-07 3.3 5.04e-07 3.3 5.04e-07 3.3 5.11e-07 3.3 5.11e-07 3.3 5.18e-07 3.3 5.18e-07 0 5.25e-07 0 5.25e-07 3.3 5.32e-07 3.3 5.32e-07 0 5.39e-07 0 5.39e-07 3.3 5.46e-07 3.3 5.46e-07 0 5.53e-07 0 5.53e-07 0 5.6e-07 0 5.6e-07 0 5.67e-07 0 5.671e-07 3.3 5.74e-07 3.3 5.741e-07 0 5.81e-07 0 5.811e-07 3.3 5.88e-07 3.3 5.881e-07 0 5.95e-07 0 5.951e-07 0 6.02e-07 0 6.021e-07 0 6.09e-07 0 6.091e-07 0 6.16e-07 0 6.161e-07 3.3 6.23e-07 3.3 6.231e-07 3.3 6.3e-07 3.3 6.301e-07 3.3 6.37e-07 3.3 6.371e-07 0 6.44e-07 0 6.441e-07 3.3 6.51e-07 3.3 6.51e-07 0 6.58e-07 0 6.58e-07 3.3 6.65e-07 3.3 6.65e-07 3.3 6.72e-07 3.3 6.72e-07 3.3 6.79e-07 3.3 6.79e-07 0 6.86e-07 0 6.86e-07 3.3 6.93e-07 3.3 6.93e-07 0 7e-07 0 7e-07 0 7.07e-07 0 7.07e-07 3.3 7.14e-07 3.3 7.14e-07 3.3 7.21e-07 3.3 7.21e-07 3.3 7.28e-07 3.3 7.28e-07 0 7.35e-07 0 7.35e-07 0 7.42e-07 0 7.42e-07 3.3 7.49e-07 3.3 7.49e-07 3.3 7.56e-07 3.3 7.56e-07 0 7.63e-07 0 7.63e-07 3.3 7.7e-07 3.3 7.7e-07 3.3 7.77e-07 3.3 7.77e-07 3.3 7.84e-07 3.3 7.841e-07 3.3 7.91e-07 3.3 7.911e-07 0 7.98e-07 0 7.981e-07 0 8.05e-07 0 8.051e-07 3.3 8.12e-07 3.3 8.121e-07 0 8.19e-07 0 8.191e-07 3.3 8.26e-07 3.3 8.261e-07 0 8.33e-07 0 8.331e-07 0 8.4e-07 0 8.401e-07 3.3 8.47e-07 3.3 8.471e-07 3.3 8.54e-07 3.3 8.541e-07 3.3 8.61e-07 3.3 8.61e-07 3.3 8.68e-07 3.3 8.68e-07 0 8.75e-07 0 8.75e-07 3.3 8.82e-07 3.3 8.82e-07 0 8.89e-07 0 8.89e-07 0 8.96e-07 0 8.96e-07 0 9.03e-07 0 9.03e-07 3.3 9.1e-07 3.3 9.1e-07 3.3 9.17e-07 3.3 9.17e-07 0 9.24e-07 0 9.24e-07 0 9.31e-07 0 9.31e-07 3.3 9.38e-07 3.3 9.38e-07 3.3 9.45e-07 3.3 9.45e-07 3.3 9.52e-07 3.3 9.52e-07 3.3 9.59e-07 3.3 9.59e-07 0 9.66e-07 0 9.66e-07 3.3 9.73e-07 3.3 9.73e-07 3.3 9.8e-07 3.3 9.8e-07 0 9.87e-07 0 9.87e-07 3.3 9.94e-07 3.3 9.94e-07 3.3 1.001e-06 3.3 1.001e-06 3.3 1.008e-06 3.3 1.008e-06 3.3 1.015e-06 3.3 1.015e-06 3.3 1.022e-06 3.3 1.022e-06 3.3 1.029e-06 3.3 1.029e-06 0 1.036e-06 0 1.036e-06 0 1.043e-06 0 1.043e-06 0 1.05e-06 0 1.05e-06 3.3 1.057e-06 3.3 1.057e-06 3.3 1.064e-06 3.3 1.064e-06 3.3 1.071e-06 3.3 1.071e-06 0 1.078e-06 0 1.078e-06 3.3 1.085e-06 3.3 1.085e-06 3.3 1.092e-06 3.3 1.092e-06 0 1.099e-06 0 1.099e-06 3.3 1.106e-06 3.3 1.106e-06 3.3 1.113e-06 3.3 1.113e-06 0 1.12e-06 0 1.12e-06 3.3 1.127e-06 3.3 1.127e-06 0 1.134e-06 0 1.134e-06 0 1.141e-06 0 1.141e-06 0 1.148e-06 0 1.148e-06 3.3 1.155e-06 3.3 1.155e-06 3.3 1.162e-06 3.3 1.162e-06 0 1.169e-06 0 1.169e-06 0 1.176e-06 0 1.176e-06 0 1.183e-06 0 1.183e-06 0 1.19e-06 0 1.19e-06 3.3 1.197e-06 3.3 1.197e-06 3.3 1.204e-06 3.3 1.204e-06 0 1.211e-06 0 1.211e-06 3.3 1.218e-06 3.3 1.218e-06 0 1.225e-06 0 1.225e-06 3.3 1.232e-06 3.3 1.232e-06 0 1.239e-06 0 1.239e-06 0 1.246e-06 0 1.246e-06 3.3 1.253e-06 3.3 1.253e-06 3.3 1.26e-06 3.3 1.26e-06 0 1.267e-06 0 1.267e-06 0 1.274e-06 0 1.274e-06 0 1.281e-06 0 1.281e-06 0 1.288e-06 0 1.288e-06 0 1.295e-06 0 1.295e-06 3.3 1.302e-06 3.3 1.302e-06 3.3 1.309e-06 3.3 1.309e-06 0 1.316e-06 0 1.316e-06 3.3 1.323e-06 3.3 1.323e-06 0 1.33e-06 0 1.33e-06 3.3 1.337e-06 3.3 1.337e-06 3.3 1.344e-06 3.3 1.344e-06 3.3 1.351e-06 3.3 1.351e-06 0 1.358e-06 0 1.358e-06 3.3 1.365e-06 3.3 1.365e-06 3.3 1.372e-06 3.3 1.372e-06 0 1.379e-06 0 1.379e-06 3.3 1.386e-06 3.3 1.386e-06 3.3 1.393e-06 3.3 1.393e-06 3.3 1.4e-06 3.3 1.4e-06 3.3 1.407e-06 3.3 1.407e-06 0 1.414e-06 0 1.414e-06 0 1.421e-06 0 1.421e-06 3.3 1.428e-06 3.3 1.428e-06 0 1.435e-06 0 1.435e-06 0 1.442e-06 0 1.442e-06 0 1.449e-06 0 1.449e-06 0 1.456e-06 0 1.456e-06 3.3 1.463e-06 3.3 1.463e-06 0 1.47e-06 0 1.47e-06 3.3 1.477e-06 3.3 1.477e-06 3.3 1.484e-06 3.3 1.484e-06 3.3 1.491e-06 3.3 1.491e-06 0 1.498e-06 0 1.498e-06 3.3 1.505e-06 3.3 1.505e-06 0 1.512e-06 0 1.512e-06 0 1.519e-06 0 1.519e-06 3.3 1.526e-06 3.3 1.526e-06 0 1.533e-06 0 1.533e-06 0 1.54e-06 0 1.54e-06 0 1.547e-06 0 1.547e-06 0 1.554e-06 0 1.554e-06 3.3 1.561e-06 3.3 1.561e-06 0 1.568e-06 0 1.568e-06 0 1.575e-06 0 1.575e-06 0 1.582e-06 0 1.582e-06 3.3 1.589e-06 3.3 1.589e-06 0 1.596e-06 0 1.596e-06 0 1.603e-06 0 1.603e-06 0 1.61e-06 0 1.61e-06 0 1.617e-06 0 1.617e-06 0 1.624e-06 0 1.624e-06 0 1.631e-06 0 1.631e-06 3.3 1.638e-06 3.3 1.638e-06 3.3 1.645e-06 3.3 1.645e-06 0 1.652e-06 0 1.652e-06 3.3 1.659e-06 3.3 1.659e-06 0 1.666e-06 0 1.666e-06 0 1.673e-06 0 1.673e-06 3.3 1.68e-06 3.3 1.68e-06 3.3 1.687e-06 3.3 1.687e-06 0 1.694e-06 0 1.694e-06 0 1.701e-06 0 1.701e-06 0 1.708e-06 0 1.708e-06 0 1.715e-06 0 1.715e-06 0 1.722e-06 0 1.722e-06 3.3 1.729e-06 3.3 1.729e-06 0 1.736e-06 0 1.736e-06 0 1.743e-06 0 1.743e-06 3.3 1.75e-06 3.3 1.75e-06 3.3 1.757e-06 3.3 1.757e-06 3.3 1.764e-06 3.3 1.764e-06 0 1.771e-06 0 1.771e-06 0 1.778e-06 0 1.778e-06 0 1.785e-06 0 1.785e-06 3.3 1.792e-06 3.3 1.792e-06 3.3 1.799e-06 3.3 1.799e-06 3.3 1.806e-06 3.3 1.806e-06 3.3 1.813e-06 3.3 1.813e-06 3.3)
VA2 A2 0 PWL(0 0 7e-09 0 7.05e-09 0 1.4e-08 0 1.405e-08 3.3 2.1e-08 3.3 2.105e-08 0 2.8e-08 0 2.805e-08 3.3 3.5e-08 3.3 3.505e-08 3.3 4.2e-08 3.3 4.205e-08 3.3 4.9e-08 3.3 4.905e-08 0 5.6e-08 0 5.605e-08 0 6.3e-08 0 6.305e-08 0 7e-08 0 7.005e-08 3.3 7.7e-08 3.3 7.705e-08 3.3 8.4e-08 3.3 8.405e-08 3.3 9.1e-08 3.3 9.105e-08 3.3 9.8e-08 3.3 9.805e-08 0 1.05e-07 0 1.051e-07 3.3 1.12e-07 3.3 1.121e-07 3.3 1.19e-07 3.3 1.19e-07 3.3 1.26e-07 3.3 1.26e-07 3.3 1.33e-07 3.3 1.33e-07 3.3 1.4e-07 3.3 1.4e-07 0 1.47e-07 0 1.471e-07 0 1.54e-07 0 1.541e-07 3.3 1.61e-07 3.3 1.611e-07 0 1.68e-07 0 1.68e-07 3.3 1.75e-07 3.3 1.75e-07 0 1.82e-07 0 1.82e-07 0 1.89e-07 0 1.89e-07 3.3 1.96e-07 3.3 1.961e-07 0 2.03e-07 0 2.031e-07 3.3 2.1e-07 3.3 2.101e-07 0 2.17e-07 0 2.171e-07 0 2.24e-07 0 2.24e-07 3.3 2.31e-07 3.3 2.31e-07 0 2.38e-07 0 2.38e-07 0 2.45e-07 0 2.45e-07 0 2.52e-07 0 2.52e-07 0 2.59e-07 0 2.59e-07 0 2.66e-07 0 2.66e-07 0 2.73e-07 0 2.73e-07 3.3 2.8e-07 3.3 2.8e-07 0 2.87e-07 0 2.871e-07 3.3 2.94e-07 3.3 2.941e-07 0 3.01e-07 0 3.011e-07 0 3.08e-07 0 3.081e-07 0 3.15e-07 0 3.151e-07 3.3 3.22e-07 3.3 3.221e-07 3.3 3.29e-07 3.3 3.29e-07 3.3 3.36e-07 3.3 3.36e-07 3.3 3.43e-07 3.3 3.43e-07 3.3 3.5e-07 3.3 3.5e-07 3.3 3.57e-07 3.3 3.57e-07 3.3 3.64e-07 3.3 3.64e-07 0 3.71e-07 0 3.71e-07 3.3 3.78e-07 3.3 3.78e-07 3.3 3.85e-07 3.3 3.85e-07 3.3 3.92e-07 3.3 3.921e-07 0 3.99e-07 0 3.991e-07 0 4.06e-07 0 4.061e-07 0 4.13e-07 0 4.131e-07 0 4.2e-07 0 4.201e-07 3.3 4.27e-07 3.3 4.271e-07 3.3 4.34e-07 3.3 4.34e-07 3.3 4.41e-07 3.3 4.41e-07 0 4.48e-07 0 4.48e-07 3.3 4.55e-07 3.3 4.55e-07 0 4.62e-07 0 4.62e-07 0 4.69e-07 0 4.69e-07 3.3 4.76e-07 3.3 4.76e-07 3.3 4.83e-07 3.3 4.83e-07 0 4.9e-07 0 4.9e-07 0 4.97e-07 0 4.97e-07 3.3 5.04e-07 3.3 5.04e-07 3.3 5.11e-07 3.3 5.11e-07 3.3 5.18e-07 3.3 5.18e-07 3.3 5.25e-07 3.3 5.25e-07 0 5.32e-07 0 5.32e-07 0 5.39e-07 0 5.39e-07 0 5.46e-07 0 5.46e-07 3.3 5.53e-07 3.3 5.53e-07 0 5.6e-07 0 5.6e-07 0 5.67e-07 0 5.671e-07 0 5.74e-07 0 5.741e-07 3.3 5.81e-07 3.3 5.811e-07 0 5.88e-07 0 5.881e-07 3.3 5.95e-07 3.3 5.951e-07 3.3 6.02e-07 3.3 6.021e-07 3.3 6.09e-07 3.3 6.091e-07 0 6.16e-07 0 6.161e-07 0 6.23e-07 0 6.231e-07 0 6.3e-07 0 6.301e-07 3.3 6.37e-07 3.3 6.371e-07 0 6.44e-07 0 6.441e-07 0 6.51e-07 0 6.51e-07 0 6.58e-07 0 6.58e-07 0 6.65e-07 0 6.65e-07 0 6.72e-07 0 6.72e-07 0 6.79e-07 0 6.79e-07 3.3 6.86e-07 3.3 6.86e-07 3.3 6.93e-07 3.3 6.93e-07 0 7e-07 0 7e-07 3.3 7.07e-07 3.3 7.07e-07 3.3 7.14e-07 3.3 7.14e-07 0 7.21e-07 0 7.21e-07 3.3 7.28e-07 3.3 7.28e-07 3.3 7.35e-07 3.3 7.35e-07 3.3 7.42e-07 3.3 7.42e-07 0 7.49e-07 0 7.49e-07 0 7.56e-07 0 7.56e-07 0 7.63e-07 0 7.63e-07 0 7.7e-07 0 7.7e-07 0 7.77e-07 0 7.77e-07 3.3 7.84e-07 3.3 7.841e-07 3.3 7.91e-07 3.3 7.911e-07 3.3 7.98e-07 3.3 7.981e-07 3.3 8.05e-07 3.3 8.051e-07 3.3 8.12e-07 3.3 8.121e-07 3.3 8.19e-07 3.3 8.191e-07 3.3 8.26e-07 3.3 8.261e-07 0 8.33e-07 0 8.331e-07 3.3 8.4e-07 3.3 8.401e-07 0 8.47e-07 0 8.471e-07 0 8.54e-07 0 8.541e-07 0 8.61e-07 0 8.61e-07 3.3 8.68e-07 3.3 8.68e-07 3.3 8.75e-07 3.3 8.75e-07 0 8.82e-07 0 8.82e-07 0 8.89e-07 0 8.89e-07 0 8.96e-07 0 8.96e-07 0 9.03e-07 0 9.03e-07 3.3 9.1e-07 3.3 9.1e-07 3.3 9.17e-07 3.3 9.17e-07 3.3 9.24e-07 3.3 9.24e-07 0 9.31e-07 0 9.31e-07 0 9.38e-07 0 9.38e-07 0 9.45e-07 0 9.45e-07 0 9.52e-07 0 9.52e-07 0 9.59e-07 0 9.59e-07 0 9.66e-07 0 9.66e-07 3.3 9.73e-07 3.3 9.73e-07 3.3 9.8e-07 3.3 9.8e-07 3.3 9.87e-07 3.3 9.87e-07 0 9.94e-07 0 9.94e-07 0 1.001e-06 0 1.001e-06 0 1.008e-06 0 1.008e-06 0 1.015e-06 0 1.015e-06 0 1.022e-06 0 1.022e-06 3.3 1.029e-06 3.3 1.029e-06 3.3 1.036e-06 3.3 1.036e-06 0 1.043e-06 0 1.043e-06 3.3 1.05e-06 3.3 1.05e-06 0 1.057e-06 0 1.057e-06 3.3 1.064e-06 3.3 1.064e-06 3.3 1.071e-06 3.3 1.071e-06 0 1.078e-06 0 1.078e-06 0 1.085e-06 0 1.085e-06 3.3 1.092e-06 3.3 1.092e-06 0 1.099e-06 0 1.099e-06 0 1.106e-06 0 1.106e-06 0 1.113e-06 0 1.113e-06 3.3 1.12e-06 3.3 1.12e-06 3.3 1.127e-06 3.3 1.127e-06 3.3 1.134e-06 3.3 1.134e-06 3.3 1.141e-06 3.3 1.141e-06 3.3 1.148e-06 3.3 1.148e-06 3.3 1.155e-06 3.3 1.155e-06 0 1.162e-06 0 1.162e-06 0 1.169e-06 0 1.169e-06 3.3 1.176e-06 3.3 1.176e-06 3.3 1.183e-06 3.3 1.183e-06 0 1.19e-06 0 1.19e-06 3.3 1.197e-06 3.3 1.197e-06 3.3 1.204e-06 3.3 1.204e-06 0 1.211e-06 0 1.211e-06 0 1.218e-06 0 1.218e-06 3.3 1.225e-06 3.3 1.225e-06 0 1.232e-06 0 1.232e-06 0 1.239e-06 0 1.239e-06 3.3 1.246e-06 3.3 1.246e-06 3.3 1.253e-06 3.3 1.253e-06 0 1.26e-06 0 1.26e-06 3.3 1.267e-06 3.3 1.267e-06 0 1.274e-06 0 1.274e-06 3.3 1.281e-06 3.3 1.281e-06 3.3 1.288e-06 3.3 1.288e-06 3.3 1.295e-06 3.3 1.295e-06 0 1.302e-06 0 1.302e-06 0 1.309e-06 0 1.309e-06 3.3 1.316e-06 3.3 1.316e-06 3.3 1.323e-06 3.3 1.323e-06 3.3 1.33e-06 3.3 1.33e-06 3.3 1.337e-06 3.3 1.337e-06 0 1.344e-06 0 1.344e-06 3.3 1.351e-06 3.3 1.351e-06 0 1.358e-06 0 1.358e-06 0 1.365e-06 0 1.365e-06 3.3 1.372e-06 3.3 1.372e-06 3.3 1.379e-06 3.3 1.379e-06 3.3 1.386e-06 3.3 1.386e-06 0 1.393e-06 0 1.393e-06 3.3 1.4e-06 3.3 1.4e-06 3.3 1.407e-06 3.3 1.407e-06 0 1.414e-06 0 1.414e-06 3.3 1.421e-06 3.3 1.421e-06 0 1.428e-06 0 1.428e-06 3.3 1.435e-06 3.3 1.435e-06 3.3 1.442e-06 3.3 1.442e-06 0 1.449e-06 0 1.449e-06 0 1.456e-06 0 1.456e-06 3.3 1.463e-06 3.3 1.463e-06 0 1.47e-06 0 1.47e-06 3.3 1.477e-06 3.3 1.477e-06 3.3 1.484e-06 3.3 1.484e-06 0 1.491e-06 0 1.491e-06 0 1.498e-06 0 1.498e-06 3.3 1.505e-06 3.3 1.505e-06 0 1.512e-06 0 1.512e-06 3.3 1.519e-06 3.3 1.519e-06 3.3 1.526e-06 3.3 1.526e-06 3.3 1.533e-06 3.3 1.533e-06 3.3 1.54e-06 3.3 1.54e-06 0 1.547e-06 0 1.547e-06 3.3 1.554e-06 3.3 1.554e-06 3.3 1.561e-06 3.3 1.561e-06 3.3 1.568e-06 3.3 1.568e-06 3.3 1.575e-06 3.3 1.575e-06 0 1.582e-06 0 1.582e-06 3.3 1.589e-06 3.3 1.589e-06 0 1.596e-06 0 1.596e-06 0 1.603e-06 0 1.603e-06 3.3 1.61e-06 3.3 1.61e-06 3.3 1.617e-06 3.3 1.617e-06 0 1.624e-06 0 1.624e-06 3.3 1.631e-06 3.3 1.631e-06 0 1.638e-06 0 1.638e-06 3.3 1.645e-06 3.3 1.645e-06 0 1.652e-06 0 1.652e-06 0 1.659e-06 0 1.659e-06 3.3 1.666e-06 3.3 1.666e-06 3.3 1.673e-06 3.3 1.673e-06 3.3 1.68e-06 3.3 1.68e-06 3.3 1.687e-06 3.3 1.687e-06 0 1.694e-06 0 1.694e-06 0 1.701e-06 0 1.701e-06 0 1.708e-06 0 1.708e-06 3.3 1.715e-06 3.3 1.715e-06 0 1.722e-06 0 1.722e-06 0 1.729e-06 0 1.729e-06 0 1.736e-06 0 1.736e-06 0 1.743e-06 0 1.743e-06 0 1.75e-06 0 1.75e-06 3.3 1.757e-06 3.3 1.757e-06 3.3 1.764e-06 3.3 1.764e-06 3.3 1.771e-06 3.3 1.771e-06 3.3 1.778e-06 3.3 1.778e-06 3.3 1.785e-06 3.3 1.785e-06 3.3 1.792e-06 3.3 1.792e-06 3.3 1.799e-06 3.3 1.799e-06 3.3 1.806e-06 3.3 1.806e-06 3.3 1.813e-06 3.3 1.813e-06 3.3)
VA3 A3 0 PWL(0 0 7e-09 0 7.05e-09 3.3 1.4e-08 3.3 1.405e-08 0 2.1e-08 0 2.105e-08 3.3 2.8e-08 3.3 2.805e-08 3.3 3.5e-08 3.3 3.505e-08 0 4.2e-08 0 4.205e-08 0 4.9e-08 0 4.905e-08 0 5.6e-08 0 5.605e-08 3.3 6.3e-08 3.3 6.305e-08 3.3 7e-08 3.3 7.005e-08 3.3 7.7e-08 3.3 7.705e-08 3.3 8.4e-08 3.3 8.405e-08 0 9.1e-08 0 9.105e-08 3.3 9.8e-08 3.3 9.805e-08 0 1.05e-07 0 1.051e-07 0 1.12e-07 0 1.121e-07 0 1.19e-07 0 1.19e-07 0 1.26e-07 0 1.26e-07 0 1.33e-07 0 1.33e-07 3.3 1.4e-07 3.3 1.4e-07 0 1.47e-07 0 1.471e-07 3.3 1.54e-07 3.3 1.541e-07 3.3 1.61e-07 3.3 1.611e-07 3.3 1.68e-07 3.3 1.68e-07 0 1.75e-07 0 1.75e-07 0 1.82e-07 0 1.82e-07 3.3 1.89e-07 3.3 1.89e-07 0 1.96e-07 0 1.961e-07 3.3 2.03e-07 3.3 2.031e-07 3.3 2.1e-07 3.3 2.101e-07 0 2.17e-07 0 2.171e-07 0 2.24e-07 0 2.24e-07 0 2.31e-07 0 2.31e-07 0 2.38e-07 0 2.38e-07 0 2.45e-07 0 2.45e-07 0 2.52e-07 0 2.52e-07 3.3 2.59e-07 3.3 2.59e-07 3.3 2.66e-07 3.3 2.66e-07 0 2.73e-07 0 2.73e-07 3.3 2.8e-07 3.3 2.8e-07 0 2.87e-07 0 2.871e-07 0 2.94e-07 0 2.941e-07 0 3.01e-07 0 3.011e-07 3.3 3.08e-07 3.3 3.081e-07 3.3 3.15e-07 3.3 3.151e-07 3.3 3.22e-07 3.3 3.221e-07 0 3.29e-07 0 3.29e-07 0 3.36e-07 0 3.36e-07 3.3 3.43e-07 3.3 3.43e-07 0 3.5e-07 0 3.5e-07 3.3 3.57e-07 3.3 3.57e-07 3.3 3.64e-07 3.3 3.64e-07 0 3.71e-07 0 3.71e-07 0 3.78e-07 0 3.78e-07 3.3 3.85e-07 3.3 3.85e-07 0 3.92e-07 0 3.921e-07 3.3 3.99e-07 3.3 3.991e-07 0 4.06e-07 0 4.061e-07 3.3 4.13e-07 3.3 4.131e-07 3.3 4.2e-07 3.3 4.201e-07 0 4.27e-07 0 4.271e-07 3.3 4.34e-07 3.3 4.34e-07 3.3 4.41e-07 3.3 4.41e-07 3.3 4.48e-07 3.3 4.48e-07 3.3 4.55e-07 3.3 4.55e-07 0 4.62e-07 0 4.62e-07 3.3 4.69e-07 3.3 4.69e-07 3.3 4.76e-07 3.3 4.76e-07 3.3 4.83e-07 3.3 4.83e-07 3.3 4.9e-07 3.3 4.9e-07 3.3 4.97e-07 3.3 4.97e-07 3.3 5.04e-07 3.3 5.04e-07 3.3 5.11e-07 3.3 5.11e-07 3.3 5.18e-07 3.3 5.18e-07 3.3 5.25e-07 3.3 5.25e-07 0 5.32e-07 0 5.32e-07 0 5.39e-07 0 5.39e-07 0 5.46e-07 0 5.46e-07 3.3 5.53e-07 3.3 5.53e-07 0 5.6e-07 0 5.6e-07 3.3 5.67e-07 3.3 5.671e-07 0 5.74e-07 0 5.741e-07 0 5.81e-07 0 5.811e-07 3.3 5.88e-07 3.3 5.881e-07 3.3 5.95e-07 3.3 5.951e-07 3.3 6.02e-07 3.3 6.021e-07 3.3 6.09e-07 3.3 6.091e-07 0 6.16e-07 0 6.161e-07 3.3 6.23e-07 3.3 6.231e-07 3.3 6.3e-07 3.3 6.301e-07 3.3 6.37e-07 3.3 6.371e-07 3.3 6.44e-07 3.3 6.441e-07 3.3 6.51e-07 3.3 6.51e-07 0 6.58e-07 0 6.58e-07 3.3 6.65e-07 3.3 6.65e-07 0 6.72e-07 0 6.72e-07 3.3 6.79e-07 3.3 6.79e-07 0 6.86e-07 0 6.86e-07 3.3 6.93e-07 3.3 6.93e-07 3.3 7e-07 3.3 7e-07 3.3 7.07e-07 3.3 7.07e-07 3.3 7.14e-07 3.3 7.14e-07 0 7.21e-07 0 7.21e-07 3.3 7.28e-07 3.3 7.28e-07 3.3 7.35e-07 3.3 7.35e-07 3.3 7.42e-07 3.3 7.42e-07 0 7.49e-07 0 7.49e-07 0 7.56e-07 0 7.56e-07 0 7.63e-07 0 7.63e-07 0 7.7e-07 0 7.7e-07 3.3 7.77e-07 3.3 7.77e-07 0 7.84e-07 0 7.841e-07 0 7.91e-07 0 7.911e-07 3.3 7.98e-07 3.3 7.981e-07 3.3 8.05e-07 3.3 8.051e-07 3.3 8.12e-07 3.3 8.121e-07 0 8.19e-07 0 8.191e-07 3.3 8.26e-07 3.3 8.261e-07 3.3 8.33e-07 3.3 8.331e-07 0 8.4e-07 0 8.401e-07 3.3 8.47e-07 3.3 8.471e-07 3.3 8.54e-07 3.3 8.541e-07 0 8.61e-07 0 8.61e-07 0 8.68e-07 0 8.68e-07 3.3 8.75e-07 3.3 8.75e-07 3.3 8.82e-07 3.3 8.82e-07 0 8.89e-07 0 8.89e-07 3.3 8.96e-07 3.3 8.96e-07 0 9.03e-07 0 9.03e-07 0 9.1e-07 0 9.1e-07 3.3 9.17e-07 3.3 9.17e-07 3.3 9.24e-07 3.3 9.24e-07 3.3 9.31e-07 3.3 9.31e-07 3.3 9.38e-07 3.3 9.38e-07 0 9.45e-07 0 9.45e-07 0 9.52e-07 0 9.52e-07 0 9.59e-07 0 9.59e-07 3.3 9.66e-07 3.3 9.66e-07 3.3 9.73e-07 3.3 9.73e-07 3.3 9.8e-07 3.3 9.8e-07 3.3 9.87e-07 3.3 9.87e-07 0 9.94e-07 0 9.94e-07 0 1.001e-06 0 1.001e-06 0 1.008e-06 0 1.008e-06 0 1.015e-06 0 1.015e-06 3.3 1.022e-06 3.3 1.022e-06 0 1.029e-06 0 1.029e-06 0 1.036e-06 0 1.036e-06 3.3 1.043e-06 3.3 1.043e-06 0 1.05e-06 0 1.05e-06 0 1.057e-06 0 1.057e-06 3.3 1.064e-06 3.3 1.064e-06 3.3 1.071e-06 3.3 1.071e-06 0 1.078e-06 0 1.078e-06 3.3 1.085e-06 3.3 1.085e-06 0 1.092e-06 0 1.092e-06 3.3 1.099e-06 3.3 1.099e-06 3.3 1.106e-06 3.3 1.106e-06 0 1.113e-06 0 1.113e-06 3.3 1.12e-06 3.3 1.12e-06 0 1.127e-06 0 1.127e-06 3.3 1.134e-06 3.3 1.134e-06 0 1.141e-06 0 1.141e-06 0 1.148e-06 0 1.148e-06 0 1.155e-06 0 1.155e-06 0 1.162e-06 0 1.162e-06 3.3 1.169e-06 3.3 1.169e-06 0 1.176e-06 0 1.176e-06 0 1.183e-06 0 1.183e-06 3.3 1.19e-06 3.3 1.19e-06 0 1.197e-06 0 1.197e-06 3.3 1.204e-06 3.3 1.204e-06 3.3 1.211e-06 3.3 1.211e-06 3.3 1.218e-06 3.3 1.218e-06 3.3 1.225e-06 3.3 1.225e-06 3.3 1.232e-06 3.3 1.232e-06 0 1.239e-06 0 1.239e-06 0 1.246e-06 0 1.246e-06 0 1.253e-06 0 1.253e-06 3.3 1.26e-06 3.3 1.26e-06 0 1.267e-06 0 1.267e-06 0 1.274e-06 0 1.274e-06 3.3 1.281e-06 3.3 1.281e-06 0 1.288e-06 0 1.288e-06 0 1.295e-06 0 1.295e-06 3.3 1.302e-06 3.3 1.302e-06 3.3 1.309e-06 3.3 1.309e-06 0 1.316e-06 0 1.316e-06 0 1.323e-06 0 1.323e-06 0 1.33e-06 0 1.33e-06 3.3 1.337e-06 3.3 1.337e-06 3.3 1.344e-06 3.3 1.344e-06 0 1.351e-06 0 1.351e-06 0 1.358e-06 0 1.358e-06 3.3 1.365e-06 3.3 1.365e-06 3.3 1.372e-06 3.3 1.372e-06 0 1.379e-06 0 1.379e-06 0 1.386e-06 0 1.386e-06 3.3 1.393e-06 3.3 1.393e-06 3.3 1.4e-06 3.3 1.4e-06 3.3 1.407e-06 3.3 1.407e-06 3.3 1.414e-06 3.3 1.414e-06 0 1.421e-06 0 1.421e-06 3.3 1.428e-06 3.3 1.428e-06 0 1.435e-06 0 1.435e-06 3.3 1.442e-06 3.3 1.442e-06 3.3 1.449e-06 3.3 1.449e-06 3.3 1.456e-06 3.3 1.456e-06 0 1.463e-06 0 1.463e-06 0 1.47e-06 0 1.47e-06 3.3 1.477e-06 3.3 1.477e-06 0 1.484e-06 0 1.484e-06 3.3 1.491e-06 3.3 1.491e-06 0 1.498e-06 0 1.498e-06 3.3 1.505e-06 3.3 1.505e-06 0 1.512e-06 0 1.512e-06 3.3 1.519e-06 3.3 1.519e-06 0 1.526e-06 0 1.526e-06 3.3 1.533e-06 3.3 1.533e-06 3.3 1.54e-06 3.3 1.54e-06 3.3 1.547e-06 3.3 1.547e-06 3.3 1.554e-06 3.3 1.554e-06 0 1.561e-06 0 1.561e-06 3.3 1.568e-06 3.3 1.568e-06 3.3 1.575e-06 3.3 1.575e-06 3.3 1.582e-06 3.3 1.582e-06 3.3 1.589e-06 3.3 1.589e-06 0 1.596e-06 0 1.596e-06 0 1.603e-06 0 1.603e-06 0 1.61e-06 0 1.61e-06 3.3 1.617e-06 3.3 1.617e-06 3.3 1.624e-06 3.3 1.624e-06 0 1.631e-06 0 1.631e-06 0 1.638e-06 0 1.638e-06 3.3 1.645e-06 3.3 1.645e-06 3.3 1.652e-06 3.3 1.652e-06 3.3 1.659e-06 3.3 1.659e-06 0 1.666e-06 0 1.666e-06 3.3 1.673e-06 3.3 1.673e-06 3.3 1.68e-06 3.3 1.68e-06 3.3 1.687e-06 3.3 1.687e-06 0 1.694e-06 0 1.694e-06 3.3 1.701e-06 3.3 1.701e-06 3.3 1.708e-06 3.3 1.708e-06 3.3 1.715e-06 3.3 1.715e-06 0 1.722e-06 0 1.722e-06 0 1.729e-06 0 1.729e-06 3.3 1.736e-06 3.3 1.736e-06 0 1.743e-06 0 1.743e-06 3.3 1.75e-06 3.3 1.75e-06 3.3 1.757e-06 3.3 1.757e-06 3.3 1.764e-06 3.3 1.764e-06 0 1.771e-06 0 1.771e-06 0 1.778e-06 0 1.778e-06 3.3 1.785e-06 3.3 1.785e-06 3.3 1.792e-06 3.3 1.792e-06 3.3 1.799e-06 3.3 1.799e-06 3.3 1.806e-06 3.3 1.806e-06 3.3 1.813e-06 3.3 1.813e-06 3.3)
VB0 B0 0 PWL(0 3.3 7e-09 3.3 7.05e-09 0 1.4e-08 0 1.405e-08 3.3 2.1e-08 3.3 2.105e-08 3.3 2.8e-08 3.3 2.805e-08 0 3.5e-08 0 3.505e-08 0 4.2e-08 0 4.205e-08 0 4.9e-08 0 4.905e-08 3.3 5.6e-08 3.3 5.605e-08 0 6.3e-08 0 6.305e-08 0 7e-08 0 7.005e-08 3.3 7.7e-08 3.3 7.705e-08 0 8.4e-08 0 8.405e-08 3.3 9.1e-08 3.3 9.105e-08 0 9.8e-08 0 9.805e-08 3.3 1.05e-07 3.3 1.051e-07 0 1.12e-07 0 1.121e-07 0 1.19e-07 0 1.19e-07 3.3 1.26e-07 3.3 1.26e-07 3.3 1.33e-07 3.3 1.33e-07 0 1.4e-07 0 1.4e-07 0 1.47e-07 0 1.471e-07 0 1.54e-07 0 1.541e-07 0 1.61e-07 0 1.611e-07 0 1.68e-07 0 1.68e-07 3.3 1.75e-07 3.3 1.75e-07 3.3 1.82e-07 3.3 1.82e-07 0 1.89e-07 0 1.89e-07 3.3 1.96e-07 3.3 1.961e-07 3.3 2.03e-07 3.3 2.031e-07 3.3 2.1e-07 3.3 2.101e-07 3.3 2.17e-07 3.3 2.171e-07 0 2.24e-07 0 2.24e-07 3.3 2.31e-07 3.3 2.31e-07 0 2.38e-07 0 2.38e-07 3.3 2.45e-07 3.3 2.45e-07 3.3 2.52e-07 3.3 2.52e-07 3.3 2.59e-07 3.3 2.59e-07 0 2.66e-07 0 2.66e-07 0 2.73e-07 0 2.73e-07 3.3 2.8e-07 3.3 2.8e-07 0 2.87e-07 0 2.871e-07 3.3 2.94e-07 3.3 2.941e-07 0 3.01e-07 0 3.011e-07 0 3.08e-07 0 3.081e-07 0 3.15e-07 0 3.151e-07 3.3 3.22e-07 3.3 3.221e-07 0 3.29e-07 0 3.29e-07 0 3.36e-07 0 3.36e-07 0 3.43e-07 0 3.43e-07 0 3.5e-07 0 3.5e-07 0 3.57e-07 0 3.57e-07 3.3 3.64e-07 3.3 3.64e-07 0 3.71e-07 0 3.71e-07 3.3 3.78e-07 3.3 3.78e-07 3.3 3.85e-07 3.3 3.85e-07 3.3 3.92e-07 3.3 3.921e-07 3.3 3.99e-07 3.3 3.991e-07 0 4.06e-07 0 4.061e-07 0 4.13e-07 0 4.131e-07 3.3 4.2e-07 3.3 4.201e-07 0 4.27e-07 0 4.271e-07 3.3 4.34e-07 3.3 4.34e-07 0 4.41e-07 0 4.41e-07 3.3 4.48e-07 3.3 4.48e-07 0 4.55e-07 0 4.55e-07 3.3 4.62e-07 3.3 4.62e-07 0 4.69e-07 0 4.69e-07 3.3 4.76e-07 3.3 4.76e-07 0 4.83e-07 0 4.83e-07 0 4.9e-07 0 4.9e-07 0 4.97e-07 0 4.97e-07 3.3 5.04e-07 3.3 5.04e-07 3.3 5.11e-07 3.3 5.11e-07 3.3 5.18e-07 3.3 5.18e-07 3.3 5.25e-07 3.3 5.25e-07 3.3 5.32e-07 3.3 5.32e-07 0 5.39e-07 0 5.39e-07 0 5.46e-07 0 5.46e-07 0 5.53e-07 0 5.53e-07 0 5.6e-07 0 5.6e-07 3.3 5.67e-07 3.3 5.671e-07 0 5.74e-07 0 5.741e-07 0 5.81e-07 0 5.811e-07 3.3 5.88e-07 3.3 5.881e-07 0 5.95e-07 0 5.951e-07 0 6.02e-07 0 6.021e-07 0 6.09e-07 0 6.091e-07 0 6.16e-07 0 6.161e-07 3.3 6.23e-07 3.3 6.231e-07 3.3 6.3e-07 3.3 6.301e-07 3.3 6.37e-07 3.3 6.371e-07 3.3 6.44e-07 3.3 6.441e-07 0 6.51e-07 0 6.51e-07 3.3 6.58e-07 3.3 6.58e-07 3.3 6.65e-07 3.3 6.65e-07 0 6.72e-07 0 6.72e-07 3.3 6.79e-07 3.3 6.79e-07 0 6.86e-07 0 6.86e-07 3.3 6.93e-07 3.3 6.93e-07 3.3 7e-07 3.3 7e-07 3.3 7.07e-07 3.3 7.07e-07 0 7.14e-07 0 7.14e-07 0 7.21e-07 0 7.21e-07 0 7.28e-07 0 7.28e-07 0 7.35e-07 0 7.35e-07 3.3 7.42e-07 3.3 7.42e-07 0 7.49e-07 0 7.49e-07 0 7.56e-07 0 7.56e-07 3.3 7.63e-07 3.3 7.63e-07 3.3 7.7e-07 3.3 7.7e-07 0 7.77e-07 0 7.77e-07 3.3 7.84e-07 3.3 7.841e-07 0 7.91e-07 0 7.911e-07 3.3 7.98e-07 3.3 7.981e-07 0 8.05e-07 0 8.051e-07 0 8.12e-07 0 8.121e-07 3.3 8.19e-07 3.3 8.191e-07 0 8.26e-07 0 8.261e-07 0 8.33e-07 0 8.331e-07 0 8.4e-07 0 8.401e-07 3.3 8.47e-07 3.3 8.471e-07 0 8.54e-07 0 8.541e-07 0 8.61e-07 0 8.61e-07 3.3 8.68e-07 3.3 8.68e-07 3.3 8.75e-07 3.3 8.75e-07 0 8.82e-07 0 8.82e-07 3.3 8.89e-07 3.3 8.89e-07 3.3 8.96e-07 3.3 8.96e-07 0 9.03e-07 0 9.03e-07 3.3 9.1e-07 3.3 9.1e-07 3.3 9.17e-07 3.3 9.17e-07 0 9.24e-07 0 9.24e-07 0 9.31e-07 0 9.31e-07 0 9.38e-07 0 9.38e-07 0 9.45e-07 0 9.45e-07 3.3 9.52e-07 3.3 9.52e-07 3.3 9.59e-07 3.3 9.59e-07 3.3 9.66e-07 3.3 9.66e-07 0 9.73e-07 0 9.73e-07 3.3 9.8e-07 3.3 9.8e-07 0 9.87e-07 0 9.87e-07 0 9.94e-07 0 9.94e-07 3.3 1.001e-06 3.3 1.001e-06 3.3 1.008e-06 3.3 1.008e-06 3.3 1.015e-06 3.3 1.015e-06 0 1.022e-06 0 1.022e-06 3.3 1.029e-06 3.3 1.029e-06 3.3 1.036e-06 3.3 1.036e-06 3.3 1.043e-06 3.3 1.043e-06 3.3 1.05e-06 3.3 1.05e-06 0 1.057e-06 0 1.057e-06 0 1.064e-06 0 1.064e-06 0 1.071e-06 0 1.071e-06 3.3 1.078e-06 3.3 1.078e-06 3.3 1.085e-06 3.3 1.085e-06 0 1.092e-06 0 1.092e-06 0 1.099e-06 0 1.099e-06 0 1.106e-06 0 1.106e-06 0 1.113e-06 0 1.113e-06 3.3 1.12e-06 3.3 1.12e-06 3.3 1.127e-06 3.3 1.127e-06 3.3 1.134e-06 3.3 1.134e-06 0 1.141e-06 0 1.141e-06 3.3 1.148e-06 3.3 1.148e-06 0 1.155e-06 0 1.155e-06 0 1.162e-06 0 1.162e-06 3.3 1.169e-06 3.3 1.169e-06 0 1.176e-06 0 1.176e-06 0 1.183e-06 0 1.183e-06 3.3 1.19e-06 3.3 1.19e-06 0 1.197e-06 0 1.197e-06 0 1.204e-06 0 1.204e-06 0 1.211e-06 0 1.211e-06 0 1.218e-06 0 1.218e-06 3.3 1.225e-06 3.3 1.225e-06 0 1.232e-06 0 1.232e-06 0 1.239e-06 0 1.239e-06 0 1.246e-06 0 1.246e-06 0 1.253e-06 0 1.253e-06 0 1.26e-06 0 1.26e-06 3.3 1.267e-06 3.3 1.267e-06 3.3 1.274e-06 3.3 1.274e-06 3.3 1.281e-06 3.3 1.281e-06 3.3 1.288e-06 3.3 1.288e-06 0 1.295e-06 0 1.295e-06 3.3 1.302e-06 3.3 1.302e-06 0 1.309e-06 0 1.309e-06 0 1.316e-06 0 1.316e-06 3.3 1.323e-06 3.3 1.323e-06 3.3 1.33e-06 3.3 1.33e-06 3.3 1.337e-06 3.3 1.337e-06 0 1.344e-06 0 1.344e-06 0 1.351e-06 0 1.351e-06 0 1.358e-06 0 1.358e-06 3.3 1.365e-06 3.3 1.365e-06 3.3 1.372e-06 3.3 1.372e-06 0 1.379e-06 0 1.379e-06 0 1.386e-06 0 1.386e-06 3.3 1.393e-06 3.3 1.393e-06 3.3 1.4e-06 3.3 1.4e-06 0 1.407e-06 0 1.407e-06 3.3 1.414e-06 3.3 1.414e-06 0 1.421e-06 0 1.421e-06 0 1.428e-06 0 1.428e-06 3.3 1.435e-06 3.3 1.435e-06 0 1.442e-06 0 1.442e-06 0 1.449e-06 0 1.449e-06 0 1.456e-06 0 1.456e-06 0 1.463e-06 0 1.463e-06 0 1.47e-06 0 1.47e-06 0 1.477e-06 0 1.477e-06 3.3 1.484e-06 3.3 1.484e-06 3.3 1.491e-06 3.3 1.491e-06 3.3 1.498e-06 3.3 1.498e-06 3.3 1.505e-06 3.3 1.505e-06 0 1.512e-06 0 1.512e-06 3.3 1.519e-06 3.3 1.519e-06 3.3 1.526e-06 3.3 1.526e-06 0 1.533e-06 0 1.533e-06 3.3 1.54e-06 3.3 1.54e-06 3.3 1.547e-06 3.3 1.547e-06 3.3 1.554e-06 3.3 1.554e-06 0 1.561e-06 0 1.561e-06 3.3 1.568e-06 3.3 1.568e-06 3.3 1.575e-06 3.3 1.575e-06 3.3 1.582e-06 3.3 1.582e-06 0 1.589e-06 0 1.589e-06 3.3 1.596e-06 3.3 1.596e-06 3.3 1.603e-06 3.3 1.603e-06 0 1.61e-06 0 1.61e-06 3.3 1.617e-06 3.3 1.617e-06 0 1.624e-06 0 1.624e-06 0 1.631e-06 0 1.631e-06 0 1.638e-06 0 1.638e-06 0 1.645e-06 0 1.645e-06 0 1.652e-06 0 1.652e-06 0 1.659e-06 0 1.659e-06 3.3 1.666e-06 3.3 1.666e-06 0 1.673e-06 0 1.673e-06 3.3 1.68e-06 3.3 1.68e-06 0 1.687e-06 0 1.687e-06 3.3 1.694e-06 3.3 1.694e-06 0 1.701e-06 0 1.701e-06 3.3 1.708e-06 3.3 1.708e-06 3.3 1.715e-06 3.3 1.715e-06 0 1.722e-06 0 1.722e-06 0 1.729e-06 0 1.729e-06 3.3 1.736e-06 3.3 1.736e-06 0 1.743e-06 0 1.743e-06 0 1.75e-06 0 1.75e-06 0 1.757e-06 0 1.757e-06 3.3 1.764e-06 3.3 1.764e-06 3.3 1.771e-06 3.3 1.771e-06 0 1.778e-06 0 1.778e-06 0 1.785e-06 0 1.785e-06 0 1.792e-06 0 1.792e-06 0 1.799e-06 0 1.799e-06 0 1.806e-06 0 1.806e-06 0 1.813e-06 0 1.813e-06 0)
VB1 B1 0 PWL(0 0 7e-09 0 7.05e-09 3.3 1.4e-08 3.3 1.405e-08 0 2.1e-08 0 2.105e-08 3.3 2.8e-08 3.3 2.805e-08 3.3 3.5e-08 3.3 3.505e-08 3.3 4.2e-08 3.3 4.205e-08 0 4.9e-08 0 4.905e-08 0 5.6e-08 0 5.605e-08 0 6.3e-08 0 6.305e-08 0 7e-08 0 7.005e-08 3.3 7.7e-08 3.3 7.705e-08 0 8.4e-08 0 8.405e-08 0 9.1e-08 0 9.105e-08 0 9.8e-08 0 9.805e-08 0 1.05e-07 0 1.051e-07 3.3 1.12e-07 3.3 1.121e-07 3.3 1.19e-07 3.3 1.19e-07 0 1.26e-07 0 1.26e-07 3.3 1.33e-07 3.3 1.33e-07 0 1.4e-07 0 1.4e-07 0 1.47e-07 0 1.471e-07 0 1.54e-07 0 1.541e-07 0 1.61e-07 0 1.611e-07 0 1.68e-07 0 1.68e-07 0 1.75e-07 0 1.75e-07 0 1.82e-07 0 1.82e-07 0 1.89e-07 0 1.89e-07 3.3 1.96e-07 3.3 1.961e-07 0 2.03e-07 0 2.031e-07 3.3 2.1e-07 3.3 2.101e-07 3.3 2.17e-07 3.3 2.171e-07 3.3 2.24e-07 3.3 2.24e-07 0 2.31e-07 0 2.31e-07 0 2.38e-07 0 2.38e-07 0 2.45e-07 0 2.45e-07 3.3 2.52e-07 3.3 2.52e-07 0 2.59e-07 0 2.59e-07 0 2.66e-07 0 2.66e-07 0 2.73e-07 0 2.73e-07 0 2.8e-07 0 2.8e-07 3.3 2.87e-07 3.3 2.871e-07 3.3 2.94e-07 3.3 2.941e-07 3.3 3.01e-07 3.3 3.011e-07 3.3 3.08e-07 3.3 3.081e-07 0 3.15e-07 0 3.151e-07 0 3.22e-07 0 3.221e-07 0 3.29e-07 0 3.29e-07 3.3 3.36e-07 3.3 3.36e-07 0 3.43e-07 0 3.43e-07 3.3 3.5e-07 3.3 3.5e-07 0 3.57e-07 0 3.57e-07 3.3 3.64e-07 3.3 3.64e-07 0 3.71e-07 0 3.71e-07 0 3.78e-07 0 3.78e-07 0 3.85e-07 0 3.85e-07 3.3 3.92e-07 3.3 3.921e-07 3.3 3.99e-07 3.3 3.991e-07 3.3 4.06e-07 3.3 4.061e-07 0 4.13e-07 0 4.131e-07 0 4.2e-07 0 4.201e-07 3.3 4.27e-07 3.3 4.271e-07 3.3 4.34e-07 3.3 4.34e-07 0 4.41e-07 0 4.41e-07 3.3 4.48e-07 3.3 4.48e-07 0 4.55e-07 0 4.55e-07 3.3 4.62e-07 3.3 4.62e-07 3.3 4.69e-07 3.3 4.69e-07 3.3 4.76e-07 3.3 4.76e-07 0 4.83e-07 0 4.83e-07 0 4.9e-07 0 4.9e-07 3.3 4.97e-07 3.3 4.97e-07 3.3 5.04e-07 3.3 5.04e-07 0 5.11e-07 0 5.11e-07 0 5.18e-07 0 5.18e-07 0 5.25e-07 0 5.25e-07 3.3 5.32e-07 3.3 5.32e-07 0 5.39e-07 0 5.39e-07 3.3 5.46e-07 3.3 5.46e-07 3.3 5.53e-07 3.3 5.53e-07 3.3 5.6e-07 3.3 5.6e-07 0 5.67e-07 0 5.671e-07 3.3 5.74e-07 3.3 5.741e-07 0 5.81e-07 0 5.811e-07 0 5.88e-07 0 5.881e-07 3.3 5.95e-07 3.3 5.951e-07 0 6.02e-07 0 6.021e-07 3.3 6.09e-07 3.3 6.091e-07 0 6.16e-07 0 6.161e-07 3.3 6.23e-07 3.3 6.231e-07 0 6.3e-07 0 6.301e-07 3.3 6.37e-07 3.3 6.371e-07 3.3 6.44e-07 3.3 6.441e-07 3.3 6.51e-07 3.3 6.51e-07 3.3 6.58e-07 3.3 6.58e-07 3.3 6.65e-07 3.3 6.65e-07 0 6.72e-07 0 6.72e-07 3.3 6.79e-07 3.3 6.79e-07 0 6.86e-07 0 6.86e-07 0 6.93e-07 0 6.93e-07 0 7e-07 0 7e-07 3.3 7.07e-07 3.3 7.07e-07 0 7.14e-07 0 7.14e-07 3.3 7.21e-07 3.3 7.21e-07 0 7.28e-07 0 7.28e-07 3.3 7.35e-07 3.3 7.35e-07 3.3 7.42e-07 3.3 7.42e-07 0 7.49e-07 0 7.49e-07 0 7.56e-07 0 7.56e-07 3.3 7.63e-07 3.3 7.63e-07 0 7.7e-07 0 7.7e-07 0 7.77e-07 0 7.77e-07 0 7.84e-07 0 7.841e-07 3.3 7.91e-07 3.3 7.911e-07 0 7.98e-07 0 7.981e-07 3.3 8.05e-07 3.3 8.051e-07 3.3 8.12e-07 3.3 8.121e-07 0 8.19e-07 0 8.191e-07 3.3 8.26e-07 3.3 8.261e-07 3.3 8.33e-07 3.3 8.331e-07 3.3 8.4e-07 3.3 8.401e-07 3.3 8.47e-07 3.3 8.471e-07 0 8.54e-07 0 8.541e-07 0 8.61e-07 0 8.61e-07 3.3 8.68e-07 3.3 8.68e-07 0 8.75e-07 0 8.75e-07 0 8.82e-07 0 8.82e-07 0 8.89e-07 0 8.89e-07 0 8.96e-07 0 8.96e-07 3.3 9.03e-07 3.3 9.03e-07 3.3 9.1e-07 3.3 9.1e-07 3.3 9.17e-07 3.3 9.17e-07 3.3 9.24e-07 3.3 9.24e-07 3.3 9.31e-07 3.3 9.31e-07 3.3 9.38e-07 3.3 9.38e-07 0 9.45e-07 0 9.45e-07 3.3 9.52e-07 3.3 9.52e-07 3.3 9.59e-07 3.3 9.59e-07 3.3 9.66e-07 3.3 9.66e-07 3.3 9.73e-07 3.3 9.73e-07 3.3 9.8e-07 3.3 9.8e-07 3.3 9.87e-07 3.3 9.87e-07 0 9.94e-07 0 9.94e-07 3.3 1.001e-06 3.3 1.001e-06 0 1.008e-06 0 1.008e-06 3.3 1.015e-06 3.3 1.015e-06 3.3 1.022e-06 3.3 1.022e-06 0 1.029e-06 0 1.029e-06 0 1.036e-06 0 1.036e-06 3.3 1.043e-06 3.3 1.043e-06 0 1.05e-06 0 1.05e-06 3.3 1.057e-06 3.3 1.057e-06 0 1.064e-06 0 1.064e-06 0 1.071e-06 0 1.071e-06 3.3 1.078e-06 3.3 1.078e-06 0 1.085e-06 0 1.085e-06 3.3 1.092e-06 3.3 1.092e-06 0 1.099e-06 0 1.099e-06 0 1.106e-06 0 1.106e-06 0 1.113e-06 0 1.113e-06 0 1.12e-06 0 1.12e-06 0 1.127e-06 0 1.127e-06 3.3 1.134e-06 3.3 1.134e-06 0 1.141e-06 0 1.141e-06 3.3 1.148e-06 3.3 1.148e-06 3.3 1.155e-06 3.3 1.155e-06 0 1.162e-06 0 1.162e-06 0 1.169e-06 0 1.169e-06 3.3 1.176e-06 3.3 1.176e-06 3.3 1.183e-06 3.3 1.183e-06 0 1.19e-06 0 1.19e-06 0 1.197e-06 0 1.197e-06 0 1.204e-06 0 1.204e-06 3.3 1.211e-06 3.3 1.211e-06 3.3 1.218e-06 3.3 1.218e-06 3.3 1.225e-06 3.3 1.225e-06 0 1.232e-06 0 1.232e-06 0 1.239e-06 0 1.239e-06 3.3 1.246e-06 3.3 1.246e-06 3.3 1.253e-06 3.3 1.253e-06 3.3 1.26e-06 3.3 1.26e-06 0 1.267e-06 0 1.267e-06 0 1.274e-06 0 1.274e-06 0 1.281e-06 0 1.281e-06 0 1.288e-06 0 1.288e-06 3.3 1.295e-06 3.3 1.295e-06 3.3 1.302e-06 3.3 1.302e-06 0 1.309e-06 0 1.309e-06 0 1.316e-06 0 1.316e-06 3.3 1.323e-06 3.3 1.323e-06 0 1.33e-06 0 1.33e-06 0 1.337e-06 0 1.337e-06 3.3 1.344e-06 3.3 1.344e-06 3.3 1.351e-06 3.3 1.351e-06 0 1.358e-06 0 1.358e-06 3.3 1.365e-06 3.3 1.365e-06 3.3 1.372e-06 3.3 1.372e-06 0 1.379e-06 0 1.379e-06 3.3 1.386e-06 3.3 1.386e-06 0 1.393e-06 0 1.393e-06 0 1.4e-06 0 1.4e-06 0 1.407e-06 0 1.407e-06 0 1.414e-06 0 1.414e-06 0 1.421e-06 0 1.421e-06 3.3 1.428e-06 3.3 1.428e-06 3.3 1.435e-06 3.3 1.435e-06 0 1.442e-06 0 1.442e-06 3.3 1.449e-06 3.3 1.449e-06 3.3 1.456e-06 3.3 1.456e-06 3.3 1.463e-06 3.3 1.463e-06 3.3 1.47e-06 3.3 1.47e-06 3.3 1.477e-06 3.3 1.477e-06 0 1.484e-06 0 1.484e-06 3.3 1.491e-06 3.3 1.491e-06 0 1.498e-06 0 1.498e-06 0 1.505e-06 0 1.505e-06 3.3 1.512e-06 3.3 1.512e-06 3.3 1.519e-06 3.3 1.519e-06 0 1.526e-06 0 1.526e-06 0 1.533e-06 0 1.533e-06 0 1.54e-06 0 1.54e-06 0 1.547e-06 0 1.547e-06 0 1.554e-06 0 1.554e-06 3.3 1.561e-06 3.3 1.561e-06 0 1.568e-06 0 1.568e-06 3.3 1.575e-06 3.3 1.575e-06 0 1.582e-06 0 1.582e-06 3.3 1.589e-06 3.3 1.589e-06 3.3 1.596e-06 3.3 1.596e-06 0 1.603e-06 0 1.603e-06 3.3 1.61e-06 3.3 1.61e-06 3.3 1.617e-06 3.3 1.617e-06 0 1.624e-06 0 1.624e-06 3.3 1.631e-06 3.3 1.631e-06 0 1.638e-06 0 1.638e-06 3.3 1.645e-06 3.3 1.645e-06 0 1.652e-06 0 1.652e-06 0 1.659e-06 0 1.659e-06 0 1.666e-06 0 1.666e-06 3.3 1.673e-06 3.3 1.673e-06 3.3 1.68e-06 3.3 1.68e-06 3.3 1.687e-06 3.3 1.687e-06 0 1.694e-06 0 1.694e-06 0 1.701e-06 0 1.701e-06 0 1.708e-06 0 1.708e-06 0 1.715e-06 0 1.715e-06 0 1.722e-06 0 1.722e-06 0 1.729e-06 0 1.729e-06 3.3 1.736e-06 3.3 1.736e-06 0 1.743e-06 0 1.743e-06 0 1.75e-06 0 1.75e-06 0 1.757e-06 0 1.757e-06 3.3 1.764e-06 3.3 1.764e-06 0 1.771e-06 0 1.771e-06 0 1.778e-06 0 1.778e-06 3.3 1.785e-06 3.3 1.785e-06 0 1.792e-06 0 1.792e-06 0 1.799e-06 0 1.799e-06 0 1.806e-06 0 1.806e-06 0 1.813e-06 0 1.813e-06 0)
VB2 B2 0 PWL(0 0 7e-09 0 7.05e-09 0 1.4e-08 0 1.405e-08 0 2.1e-08 0 2.105e-08 3.3 2.8e-08 3.3 2.805e-08 3.3 3.5e-08 3.3 3.505e-08 0 4.2e-08 0 4.205e-08 0 4.9e-08 0 4.905e-08 0 5.6e-08 0 5.605e-08 0 6.3e-08 0 6.305e-08 0 7e-08 0 7.005e-08 0 7.7e-08 0 7.705e-08 0 8.4e-08 0 8.405e-08 0 9.1e-08 0 9.105e-08 3.3 9.8e-08 3.3 9.805e-08 3.3 1.05e-07 3.3 1.051e-07 3.3 1.12e-07 3.3 1.121e-07 3.3 1.19e-07 3.3 1.19e-07 0 1.26e-07 0 1.26e-07 0 1.33e-07 0 1.33e-07 3.3 1.4e-07 3.3 1.4e-07 0 1.47e-07 0 1.471e-07 3.3 1.54e-07 3.3 1.541e-07 0 1.61e-07 0 1.611e-07 0 1.68e-07 0 1.68e-07 3.3 1.75e-07 3.3 1.75e-07 3.3 1.82e-07 3.3 1.82e-07 3.3 1.89e-07 3.3 1.89e-07 3.3 1.96e-07 3.3 1.961e-07 3.3 2.03e-07 3.3 2.031e-07 0 2.1e-07 0 2.101e-07 3.3 2.17e-07 3.3 2.171e-07 0 2.24e-07 0 2.24e-07 0 2.31e-07 0 2.31e-07 3.3 2.38e-07 3.3 2.38e-07 0 2.45e-07 0 2.45e-07 0 2.52e-07 0 2.52e-07 3.3 2.59e-07 3.3 2.59e-07 0 2.66e-07 0 2.66e-07 0 2.73e-07 0 2.73e-07 3.3 2.8e-07 3.3 2.8e-07 3.3 2.87e-07 3.3 2.871e-07 3.3 2.94e-07 3.3 2.941e-07 0 3.01e-07 0 3.011e-07 0 3.08e-07 0 3.081e-07 3.3 3.15e-07 3.3 3.151e-07 3.3 3.22e-07 3.3 3.221e-07 3.3 3.29e-07 3.3 3.29e-07 3.3 3.36e-07 3.3 3.36e-07 3.3 3.43e-07 3.3 3.43e-07 0 3.5e-07 0 3.5e-07 0 3.57e-07 0 3.57e-07 3.3 3.64e-07 3.3 3.64e-07 0 3.71e-07 0 3.71e-07 0 3.78e-07 0 3.78e-07 0 3.85e-07 0 3.85e-07 0 3.92e-07 0 3.921e-07 0 3.99e-07 0 3.991e-07 0 4.06e-07 0 4.061e-07 3.3 4.13e-07 3.3 4.131e-07 3.3 4.2e-07 3.3 4.201e-07 0 4.27e-07 0 4.271e-07 3.3 4.34e-07 3.3 4.34e-07 3.3 4.41e-07 3.3 4.41e-07 0 4.48e-07 0 4.48e-07 3.3 4.55e-07 3.3 4.55e-07 3.3 4.62e-07 3.3 4.62e-07 3.3 4.69e-07 3.3 4.69e-07 3.3 4.76e-07 3.3 4.76e-07 3.3 4.83e-07 3.3 4.83e-07 0 4.9e-07 0 4.9e-07 3.3 4.97e-07 3.3 4.97e-07 0 5.04e-07 0 5.04e-07 0 5.11e-07 0 5.11e-07 3.3 5.18e-07 3.3 5.18e-07 0 5.25e-07 0 5.25e-07 3.3 5.32e-07 3.3 5.32e-07 3.3 5.39e-07 3.3 5.39e-07 3.3 5.46e-07 3.3 5.46e-07 3.3 5.53e-07 3.3 5.53e-07 0 5.6e-07 0 5.6e-07 0 5.67e-07 0 5.671e-07 3.3 5.74e-07 3.3 5.741e-07 0 5.81e-07 0 5.811e-07 3.3 5.88e-07 3.3 5.881e-07 0 5.95e-07 0 5.951e-07 3.3 6.02e-07 3.3 6.021e-07 3.3 6.09e-07 3.3 6.091e-07 3.3 6.16e-07 3.3 6.161e-07 3.3 6.23e-07 3.3 6.231e-07 3.3 6.3e-07 3.3 6.301e-07 0 6.37e-07 0 6.371e-07 0 6.44e-07 0 6.441e-07 3.3 6.51e-07 3.3 6.51e-07 3.3 6.58e-07 3.3 6.58e-07 3.3 6.65e-07 3.3 6.65e-07 0 6.72e-07 0 6.72e-07 0 6.79e-07 0 6.79e-07 3.3 6.86e-07 3.3 6.86e-07 0 6.93e-07 0 6.93e-07 3.3 7e-07 3.3 7e-07 0 7.07e-07 0 7.07e-07 0 7.14e-07 0 7.14e-07 3.3 7.21e-07 3.3 7.21e-07 3.3 7.28e-07 3.3 7.28e-07 0 7.35e-07 0 7.35e-07 3.3 7.42e-07 3.3 7.42e-07 3.3 7.49e-07 3.3 7.49e-07 0 7.56e-07 0 7.56e-07 0 7.63e-07 0 7.63e-07 3.3 7.7e-07 3.3 7.7e-07 3.3 7.77e-07 3.3 7.77e-07 0 7.84e-07 0 7.841e-07 0 7.91e-07 0 7.911e-07 0 7.98e-07 0 7.981e-07 3.3 8.05e-07 3.3 8.051e-07 3.3 8.12e-07 3.3 8.121e-07 0 8.19e-07 0 8.191e-07 3.3 8.26e-07 3.3 8.261e-07 3.3 8.33e-07 3.3 8.331e-07 0 8.4e-07 0 8.401e-07 0 8.47e-07 0 8.471e-07 3.3 8.54e-07 3.3 8.541e-07 3.3 8.61e-07 3.3 8.61e-07 3.3 8.68e-07 3.3 8.68e-07 3.3 8.75e-07 3.3 8.75e-07 0 8.82e-07 0 8.82e-07 0 8.89e-07 0 8.89e-07 0 8.96e-07 0 8.96e-07 0 9.03e-07 0 9.03e-07 3.3 9.1e-07 3.3 9.1e-07 0 9.17e-07 0 9.17e-07 3.3 9.24e-07 3.3 9.24e-07 3.3 9.31e-07 3.3 9.31e-07 3.3 9.38e-07 3.3 9.38e-07 3.3 9.45e-07 3.3 9.45e-07 3.3 9.52e-07 3.3 9.52e-07 0 9.59e-07 0 9.59e-07 3.3 9.66e-07 3.3 9.66e-07 3.3 9.73e-07 3.3 9.73e-07 0 9.8e-07 0 9.8e-07 0 9.87e-07 0 9.87e-07 0 9.94e-07 0 9.94e-07 3.3 1.001e-06 3.3 1.001e-06 3.3 1.008e-06 3.3 1.008e-06 0 1.015e-06 0 1.015e-06 3.3 1.022e-06 3.3 1.022e-06 3.3 1.029e-06 3.3 1.029e-06 3.3 1.036e-06 3.3 1.036e-06 3.3 1.043e-06 3.3 1.043e-06 3.3 1.05e-06 3.3 1.05e-06 3.3 1.057e-06 3.3 1.057e-06 0 1.064e-06 0 1.064e-06 0 1.071e-06 0 1.071e-06 3.3 1.078e-06 3.3 1.078e-06 0 1.085e-06 0 1.085e-06 3.3 1.092e-06 3.3 1.092e-06 0 1.099e-06 0 1.099e-06 0 1.106e-06 0 1.106e-06 0 1.113e-06 0 1.113e-06 3.3 1.12e-06 3.3 1.12e-06 3.3 1.127e-06 3.3 1.127e-06 0 1.134e-06 0 1.134e-06 3.3 1.141e-06 3.3 1.141e-06 0 1.148e-06 0 1.148e-06 3.3 1.155e-06 3.3 1.155e-06 0 1.162e-06 0 1.162e-06 3.3 1.169e-06 3.3 1.169e-06 3.3 1.176e-06 3.3 1.176e-06 0 1.183e-06 0 1.183e-06 0 1.19e-06 0 1.19e-06 0 1.197e-06 0 1.197e-06 0 1.204e-06 0 1.204e-06 0 1.211e-06 0 1.211e-06 3.3 1.218e-06 3.3 1.218e-06 0 1.225e-06 0 1.225e-06 3.3 1.232e-06 3.3 1.232e-06 3.3 1.239e-06 3.3 1.239e-06 3.3 1.246e-06 3.3 1.246e-06 3.3 1.253e-06 3.3 1.253e-06 3.3 1.26e-06 3.3 1.26e-06 3.3 1.267e-06 3.3 1.267e-06 3.3 1.274e-06 3.3 1.274e-06 3.3 1.281e-06 3.3 1.281e-06 3.3 1.288e-06 3.3 1.288e-06 3.3 1.295e-06 3.3 1.295e-06 3.3 1.302e-06 3.3 1.302e-06 3.3 1.309e-06 3.3 1.309e-06 0 1.316e-06 0 1.316e-06 3.3 1.323e-06 3.3 1.323e-06 3.3 1.33e-06 3.3 1.33e-06 3.3 1.337e-06 3.3 1.337e-06 3.3 1.344e-06 3.3 1.344e-06 3.3 1.351e-06 3.3 1.351e-06 3.3 1.358e-06 3.3 1.358e-06 3.3 1.365e-06 3.3 1.365e-06 0 1.372e-06 0 1.372e-06 3.3 1.379e-06 3.3 1.379e-06 3.3 1.386e-06 3.3 1.386e-06 3.3 1.393e-06 3.3 1.393e-06 3.3 1.4e-06 3.3 1.4e-06 0 1.407e-06 0 1.407e-06 3.3 1.414e-06 3.3 1.414e-06 0 1.421e-06 0 1.421e-06 0 1.428e-06 0 1.428e-06 3.3 1.435e-06 3.3 1.435e-06 0 1.442e-06 0 1.442e-06 0 1.449e-06 0 1.449e-06 0 1.456e-06 0 1.456e-06 0 1.463e-06 0 1.463e-06 0 1.47e-06 0 1.47e-06 0 1.477e-06 0 1.477e-06 3.3 1.484e-06 3.3 1.484e-06 3.3 1.491e-06 3.3 1.491e-06 3.3 1.498e-06 3.3 1.498e-06 0 1.505e-06 0 1.505e-06 0 1.512e-06 0 1.512e-06 3.3 1.519e-06 3.3 1.519e-06 3.3 1.526e-06 3.3 1.526e-06 3.3 1.533e-06 3.3 1.533e-06 3.3 1.54e-06 3.3 1.54e-06 0 1.547e-06 0 1.547e-06 3.3 1.554e-06 3.3 1.554e-06 0 1.561e-06 0 1.561e-06 3.3 1.568e-06 3.3 1.568e-06 0 1.575e-06 0 1.575e-06 3.3 1.582e-06 3.3 1.582e-06 3.3 1.589e-06 3.3 1.589e-06 0 1.596e-06 0 1.596e-06 0 1.603e-06 0 1.603e-06 0 1.61e-06 0 1.61e-06 0 1.617e-06 0 1.617e-06 3.3 1.624e-06 3.3 1.624e-06 3.3 1.631e-06 3.3 1.631e-06 0 1.638e-06 0 1.638e-06 0 1.645e-06 0 1.645e-06 0 1.652e-06 0 1.652e-06 3.3 1.659e-06 3.3 1.659e-06 3.3 1.666e-06 3.3 1.666e-06 3.3 1.673e-06 3.3 1.673e-06 0 1.68e-06 0 1.68e-06 3.3 1.687e-06 3.3 1.687e-06 0 1.694e-06 0 1.694e-06 3.3 1.701e-06 3.3 1.701e-06 0 1.708e-06 0 1.708e-06 0 1.715e-06 0 1.715e-06 0 1.722e-06 0 1.722e-06 0 1.729e-06 0 1.729e-06 0 1.736e-06 0 1.736e-06 0 1.743e-06 0 1.743e-06 3.3 1.75e-06 3.3 1.75e-06 3.3 1.757e-06 3.3 1.757e-06 0 1.764e-06 0 1.764e-06 3.3 1.771e-06 3.3 1.771e-06 3.3 1.778e-06 3.3 1.778e-06 0 1.785e-06 0 1.785e-06 3.3 1.792e-06 3.3 1.792e-06 0 1.799e-06 0 1.799e-06 0 1.806e-06 0 1.806e-06 0 1.813e-06 0 1.813e-06 0)
VB3 B3 0 PWL(0 0 7e-09 0 7.05e-09 3.3 1.4e-08 3.3 1.405e-08 3.3 2.1e-08 3.3 2.105e-08 0 2.8e-08 0 2.805e-08 3.3 3.5e-08 3.3 3.505e-08 0 4.2e-08 0 4.205e-08 0 4.9e-08 0 4.905e-08 3.3 5.6e-08 3.3 5.605e-08 3.3 6.3e-08 3.3 6.305e-08 3.3 7e-08 3.3 7.005e-08 3.3 7.7e-08 3.3 7.705e-08 3.3 8.4e-08 3.3 8.405e-08 0 9.1e-08 0 9.105e-08 3.3 9.8e-08 3.3 9.805e-08 3.3 1.05e-07 3.3 1.051e-07 0 1.12e-07 0 1.121e-07 3.3 1.19e-07 3.3 1.19e-07 0 1.26e-07 0 1.26e-07 0 1.33e-07 0 1.33e-07 3.3 1.4e-07 3.3 1.4e-07 3.3 1.47e-07 3.3 1.471e-07 3.3 1.54e-07 3.3 1.541e-07 3.3 1.61e-07 3.3 1.611e-07 3.3 1.68e-07 3.3 1.68e-07 0 1.75e-07 0 1.75e-07 3.3 1.82e-07 3.3 1.82e-07 3.3 1.89e-07 3.3 1.89e-07 3.3 1.96e-07 3.3 1.961e-07 0 2.03e-07 0 2.031e-07 3.3 2.1e-07 3.3 2.101e-07 0 2.17e-07 0 2.171e-07 0 2.24e-07 0 2.24e-07 3.3 2.31e-07 3.3 2.31e-07 0 2.38e-07 0 2.38e-07 0 2.45e-07 0 2.45e-07 3.3 2.52e-07 3.3 2.52e-07 0 2.59e-07 0 2.59e-07 0 2.66e-07 0 2.66e-07 3.3 2.73e-07 3.3 2.73e-07 0 2.8e-07 0 2.8e-07 3.3 2.87e-07 3.3 2.871e-07 3.3 2.94e-07 3.3 2.941e-07 0 3.01e-07 0 3.011e-07 3.3 3.08e-07 3.3 3.081e-07 3.3 3.15e-07 3.3 3.151e-07 0 3.22e-07 0 3.221e-07 0 3.29e-07 0 3.29e-07 3.3 3.36e-07 3.3 3.36e-07 3.3 3.43e-07 3.3 3.43e-07 0 3.5e-07 0 3.5e-07 0 3.57e-07 0 3.57e-07 0 3.64e-07 0 3.64e-07 3.3 3.71e-07 3.3 3.71e-07 0 3.78e-07 0 3.78e-07 3.3 3.85e-07 3.3 3.85e-07 3.3 3.92e-07 3.3 3.921e-07 0 3.99e-07 0 3.991e-07 0 4.06e-07 0 4.061e-07 0 4.13e-07 0 4.131e-07 3.3 4.2e-07 3.3 4.201e-07 3.3 4.27e-07 3.3 4.271e-07 3.3 4.34e-07 3.3 4.34e-07 3.3 4.41e-07 3.3 4.41e-07 3.3 4.48e-07 3.3 4.48e-07 0 4.55e-07 0 4.55e-07 0 4.62e-07 0 4.62e-07 0 4.69e-07 0 4.69e-07 3.3 4.76e-07 3.3 4.76e-07 3.3 4.83e-07 3.3 4.83e-07 3.3 4.9e-07 3.3 4.9e-07 3.3 4.97e-07 3.3 4.97e-07 0 5.04e-07 0 5.04e-07 0 5.11e-07 0 5.11e-07 3.3 5.18e-07 3.3 5.18e-07 3.3 5.25e-07 3.3 5.25e-07 3.3 5.32e-07 3.3 5.32e-07 3.3 5.39e-07 3.3 5.39e-07 0 5.46e-07 0 5.46e-07 3.3 5.53e-07 3.3 5.53e-07 0 5.6e-07 0 5.6e-07 3.3 5.67e-07 3.3 5.671e-07 3.3 5.74e-07 3.3 5.741e-07 3.3 5.81e-07 3.3 5.811e-07 3.3 5.88e-07 3.3 5.881e-07 3.3 5.95e-07 3.3 5.951e-07 3.3 6.02e-07 3.3 6.021e-07 3.3 6.09e-07 3.3 6.091e-07 3.3 6.16e-07 3.3 6.161e-07 0 6.23e-07 0 6.231e-07 3.3 6.3e-07 3.3 6.301e-07 3.3 6.37e-07 3.3 6.371e-07 3.3 6.44e-07 3.3 6.441e-07 3.3 6.51e-07 3.3 6.51e-07 0 6.58e-07 0 6.58e-07 3.3 6.65e-07 3.3 6.65e-07 3.3 6.72e-07 3.3 6.72e-07 0 6.79e-07 0 6.79e-07 0 6.86e-07 0 6.86e-07 3.3 6.93e-07 3.3 6.93e-07 0 7e-07 0 7e-07 0 7.07e-07 0 7.07e-07 3.3 7.14e-07 3.3 7.14e-07 0 7.21e-07 0 7.21e-07 3.3 7.28e-07 3.3 7.28e-07 0 7.35e-07 0 7.35e-07 3.3 7.42e-07 3.3 7.42e-07 0 7.49e-07 0 7.49e-07 3.3 7.56e-07 3.3 7.56e-07 0 7.63e-07 0 7.63e-07 3.3 7.7e-07 3.3 7.7e-07 3.3 7.77e-07 3.3 7.77e-07 3.3 7.84e-07 3.3 7.841e-07 3.3 7.91e-07 3.3 7.911e-07 0 7.98e-07 0 7.981e-07 0 8.05e-07 0 8.051e-07 0 8.12e-07 0 8.121e-07 0 8.19e-07 0 8.191e-07 3.3 8.26e-07 3.3 8.261e-07 0 8.33e-07 0 8.331e-07 3.3 8.4e-07 3.3 8.401e-07 0 8.47e-07 0 8.471e-07 3.3 8.54e-07 3.3 8.541e-07 0 8.61e-07 0 8.61e-07 0 8.68e-07 0 8.68e-07 3.3 8.75e-07 3.3 8.75e-07 0 8.82e-07 0 8.82e-07 0 8.89e-07 0 8.89e-07 0 8.96e-07 0 8.96e-07 3.3 9.03e-07 3.3 9.03e-07 3.3 9.1e-07 3.3 9.1e-07 3.3 9.17e-07 3.3 9.17e-07 3.3 9.24e-07 3.3 9.24e-07 0 9.31e-07 0 9.31e-07 0 9.38e-07 0 9.38e-07 3.3 9.45e-07 3.3 9.45e-07 3.3 9.52e-07 3.3 9.52e-07 0 9.59e-07 0 9.59e-07 0 9.66e-07 0 9.66e-07 0 9.73e-07 0 9.73e-07 3.3 9.8e-07 3.3 9.8e-07 3.3 9.87e-07 3.3 9.87e-07 0 9.94e-07 0 9.94e-07 0 1.001e-06 0 1.001e-06 0 1.008e-06 0 1.008e-06 0 1.015e-06 0 1.015e-06 0 1.022e-06 0 1.022e-06 3.3 1.029e-06 3.3 1.029e-06 3.3 1.036e-06 3.3 1.036e-06 3.3 1.043e-06 3.3 1.043e-06 3.3 1.05e-06 3.3 1.05e-06 0 1.057e-06 0 1.057e-06 3.3 1.064e-06 3.3 1.064e-06 0 1.071e-06 0 1.071e-06 0 1.078e-06 0 1.078e-06 3.3 1.085e-06 3.3 1.085e-06 0 1.092e-06 0 1.092e-06 0 1.099e-06 0 1.099e-06 3.3 1.106e-06 3.3 1.106e-06 3.3 1.113e-06 3.3 1.113e-06 3.3 1.12e-06 3.3 1.12e-06 3.3 1.127e-06 3.3 1.127e-06 3.3 1.134e-06 3.3 1.134e-06 3.3 1.141e-06 3.3 1.141e-06 0 1.148e-06 0 1.148e-06 0 1.155e-06 0 1.155e-06 0 1.162e-06 0 1.162e-06 3.3 1.169e-06 3.3 1.169e-06 0 1.176e-06 0 1.176e-06 0 1.183e-06 0 1.183e-06 0 1.19e-06 0 1.19e-06 3.3 1.197e-06 3.3 1.197e-06 0 1.204e-06 0 1.204e-06 0 1.211e-06 0 1.211e-06 3.3 1.218e-06 3.3 1.218e-06 0 1.225e-06 0 1.225e-06 0 1.232e-06 0 1.232e-06 3.3 1.239e-06 3.3 1.239e-06 0 1.246e-06 0 1.246e-06 0 1.253e-06 0 1.253e-06 0 1.26e-06 0 1.26e-06 3.3 1.267e-06 3.3 1.267e-06 3.3 1.274e-06 3.3 1.274e-06 3.3 1.281e-06 3.3 1.281e-06 0 1.288e-06 0 1.288e-06 3.3 1.295e-06 3.3 1.295e-06 3.3 1.302e-06 3.3 1.302e-06 3.3 1.309e-06 3.3 1.309e-06 0 1.316e-06 0 1.316e-06 3.3 1.323e-06 3.3 1.323e-06 3.3 1.33e-06 3.3 1.33e-06 3.3 1.337e-06 3.3 1.337e-06 3.3 1.344e-06 3.3 1.344e-06 0 1.351e-06 0 1.351e-06 3.3 1.358e-06 3.3 1.358e-06 0 1.365e-06 0 1.365e-06 3.3 1.372e-06 3.3 1.372e-06 0 1.379e-06 0 1.379e-06 0 1.386e-06 0 1.386e-06 3.3 1.393e-06 3.3 1.393e-06 3.3 1.4e-06 3.3 1.4e-06 0 1.407e-06 0 1.407e-06 0 1.414e-06 0 1.414e-06 0 1.421e-06 0 1.421e-06 3.3 1.428e-06 3.3 1.428e-06 3.3 1.435e-06 3.3 1.435e-06 3.3 1.442e-06 3.3 1.442e-06 0 1.449e-06 0 1.449e-06 3.3 1.456e-06 3.3 1.456e-06 3.3 1.463e-06 3.3 1.463e-06 0 1.47e-06 0 1.47e-06 0 1.477e-06 0 1.477e-06 3.3 1.484e-06 3.3 1.484e-06 3.3 1.491e-06 3.3 1.491e-06 0 1.498e-06 0 1.498e-06 3.3 1.505e-06 3.3 1.505e-06 3.3 1.512e-06 3.3 1.512e-06 3.3 1.519e-06 3.3 1.519e-06 3.3 1.526e-06 3.3 1.526e-06 3.3 1.533e-06 3.3 1.533e-06 0 1.54e-06 0 1.54e-06 0 1.547e-06 0 1.547e-06 3.3 1.554e-06 3.3 1.554e-06 3.3 1.561e-06 3.3 1.561e-06 0 1.568e-06 0 1.568e-06 3.3 1.575e-06 3.3 1.575e-06 3.3 1.582e-06 3.3 1.582e-06 0 1.589e-06 0 1.589e-06 3.3 1.596e-06 3.3 1.596e-06 0 1.603e-06 0 1.603e-06 3.3 1.61e-06 3.3 1.61e-06 0 1.617e-06 0 1.617e-06 3.3 1.624e-06 3.3 1.624e-06 3.3 1.631e-06 3.3 1.631e-06 3.3 1.638e-06 3.3 1.638e-06 3.3 1.645e-06 3.3 1.645e-06 3.3 1.652e-06 3.3 1.652e-06 3.3 1.659e-06 3.3 1.659e-06 3.3 1.666e-06 3.3 1.666e-06 3.3 1.673e-06 3.3 1.673e-06 3.3 1.68e-06 3.3 1.68e-06 3.3 1.687e-06 3.3 1.687e-06 3.3 1.694e-06 3.3 1.694e-06 3.3 1.701e-06 3.3 1.701e-06 0 1.708e-06 0 1.708e-06 0 1.715e-06 0 1.715e-06 3.3 1.722e-06 3.3 1.722e-06 0 1.729e-06 0 1.729e-06 3.3 1.736e-06 3.3 1.736e-06 0 1.743e-06 0 1.743e-06 3.3 1.75e-06 3.3 1.75e-06 0 1.757e-06 0 1.757e-06 3.3 1.764e-06 3.3 1.764e-06 0 1.771e-06 0 1.771e-06 3.3 1.778e-06 3.3 1.778e-06 3.3 1.785e-06 3.3 1.785e-06 0 1.792e-06 0 1.792e-06 0 1.799e-06 0 1.799e-06 0 1.806e-06 0 1.806e-06 0 1.813e-06 0 1.813e-06 0)
VS0 S0 0 PWL(0 0 7e-09 0 7.05e-09 0 1.4e-08 0 1.405e-08 0 2.1e-08 0 2.105e-08 0 2.8e-08 0 2.805e-08 0 3.5e-08 0 3.505e-08 0 4.2e-08 0 4.205e-08 0 4.9e-08 0 4.905e-08 0 5.6e-08 0 5.605e-08 0 6.3e-08 0 6.305e-08 0 7e-08 0 7.005e-08 0 7.7e-08 0 7.705e-08 0 8.4e-08 0 8.405e-08 0 9.1e-08 0 9.105e-08 0 9.8e-08 0 9.805e-08 0 1.05e-07 0 1.051e-07 0 1.12e-07 0 1.121e-07 3.3 1.19e-07 3.3 1.19e-07 3.3 1.26e-07 3.3 1.26e-07 3.3 1.33e-07 3.3 1.33e-07 3.3 1.4e-07 3.3 1.4e-07 3.3 1.47e-07 3.3 1.471e-07 3.3 1.54e-07 3.3 1.541e-07 3.3 1.61e-07 3.3 1.611e-07 3.3 1.68e-07 3.3 1.68e-07 3.3 1.75e-07 3.3 1.75e-07 3.3 1.82e-07 3.3 1.82e-07 3.3 1.89e-07 3.3 1.89e-07 3.3 1.96e-07 3.3 1.961e-07 3.3 2.03e-07 3.3 2.031e-07 3.3 2.1e-07 3.3 2.101e-07 3.3 2.17e-07 3.3 2.171e-07 3.3 2.24e-07 3.3 2.24e-07 0 2.31e-07 0 2.31e-07 0 2.38e-07 0 2.38e-07 0 2.45e-07 0 2.45e-07 0 2.52e-07 0 2.52e-07 0 2.59e-07 0 2.59e-07 0 2.66e-07 0 2.66e-07 0 2.73e-07 0 2.73e-07 0 2.8e-07 0 2.8e-07 0 2.87e-07 0 2.871e-07 0 2.94e-07 0 2.941e-07 0 3.01e-07 0 3.011e-07 0 3.08e-07 0 3.081e-07 0 3.15e-07 0 3.151e-07 0 3.22e-07 0 3.221e-07 0 3.29e-07 0 3.29e-07 0 3.36e-07 0 3.36e-07 3.3 3.43e-07 3.3 3.43e-07 3.3 3.5e-07 3.3 3.5e-07 3.3 3.57e-07 3.3 3.57e-07 3.3 3.64e-07 3.3 3.64e-07 3.3 3.71e-07 3.3 3.71e-07 3.3 3.78e-07 3.3 3.78e-07 3.3 3.85e-07 3.3 3.85e-07 3.3 3.92e-07 3.3 3.921e-07 3.3 3.99e-07 3.3 3.991e-07 3.3 4.06e-07 3.3 4.061e-07 3.3 4.13e-07 3.3 4.131e-07 3.3 4.2e-07 3.3 4.201e-07 3.3 4.27e-07 3.3 4.271e-07 3.3 4.34e-07 3.3 4.34e-07 3.3 4.41e-07 3.3 4.41e-07 3.3 4.48e-07 3.3 4.48e-07 0 4.55e-07 0 4.55e-07 0 4.62e-07 0 4.62e-07 0 4.69e-07 0 4.69e-07 0 4.76e-07 0 4.76e-07 0 4.83e-07 0 4.83e-07 0 4.9e-07 0 4.9e-07 0 4.97e-07 0 4.97e-07 0 5.04e-07 0 5.04e-07 0 5.11e-07 0 5.11e-07 0 5.18e-07 0 5.18e-07 0 5.25e-07 0 5.25e-07 0 5.32e-07 0 5.32e-07 0 5.39e-07 0 5.39e-07 0 5.46e-07 0 5.46e-07 0 5.53e-07 0 5.53e-07 0 5.6e-07 0 5.6e-07 3.3 5.67e-07 3.3 5.671e-07 3.3 5.74e-07 3.3 5.741e-07 3.3 5.81e-07 3.3 5.811e-07 3.3 5.88e-07 3.3 5.881e-07 3.3 5.95e-07 3.3 5.951e-07 3.3 6.02e-07 3.3 6.021e-07 3.3 6.09e-07 3.3 6.091e-07 3.3 6.16e-07 3.3 6.161e-07 3.3 6.23e-07 3.3 6.231e-07 3.3 6.3e-07 3.3 6.301e-07 3.3 6.37e-07 3.3 6.371e-07 3.3 6.44e-07 3.3 6.441e-07 3.3 6.51e-07 3.3 6.51e-07 3.3 6.58e-07 3.3 6.58e-07 3.3 6.65e-07 3.3 6.65e-07 3.3 6.72e-07 3.3 6.72e-07 0 6.79e-07 0 6.79e-07 0 6.86e-07 0 6.86e-07 0 6.93e-07 0 6.93e-07 0 7e-07 0 7e-07 0 7.07e-07 0 7.07e-07 0 7.14e-07 0 7.14e-07 0 7.21e-07 0 7.21e-07 0 7.28e-07 0 7.28e-07 0 7.35e-07 0 7.35e-07 0 7.42e-07 0 7.42e-07 0 7.49e-07 0 7.49e-07 0 7.56e-07 0 7.56e-07 0 7.63e-07 0 7.63e-07 0 7.7e-07 0 7.7e-07 0 7.77e-07 0 7.77e-07 0 7.84e-07 0 7.841e-07 3.3 7.91e-07 3.3 7.911e-07 3.3 7.98e-07 3.3 7.981e-07 3.3 8.05e-07 3.3 8.051e-07 3.3 8.12e-07 3.3 8.121e-07 3.3 8.19e-07 3.3 8.191e-07 3.3 8.26e-07 3.3 8.261e-07 3.3 8.33e-07 3.3 8.331e-07 3.3 8.4e-07 3.3 8.401e-07 3.3 8.47e-07 3.3 8.471e-07 3.3 8.54e-07 3.3 8.541e-07 3.3 8.61e-07 3.3 8.61e-07 3.3 8.68e-07 3.3 8.68e-07 3.3 8.75e-07 3.3 8.75e-07 3.3 8.82e-07 3.3 8.82e-07 3.3 8.89e-07 3.3 8.89e-07 3.3 8.96e-07 3.3 8.96e-07 0 9.03e-07 0 9.03e-07 0 9.1e-07 0 9.1e-07 0 9.17e-07 0 9.17e-07 0 9.24e-07 0 9.24e-07 0 9.31e-07 0 9.31e-07 0 9.38e-07 0 9.38e-07 0 9.45e-07 0 9.45e-07 0 9.52e-07 0 9.52e-07 0 9.59e-07 0 9.59e-07 0 9.66e-07 0 9.66e-07 0 9.73e-07 0 9.73e-07 0 9.8e-07 0 9.8e-07 0 9.87e-07 0 9.87e-07 0 9.94e-07 0 9.94e-07 0 1.001e-06 0 1.001e-06 0 1.008e-06 0 1.008e-06 3.3 1.015e-06 3.3 1.015e-06 3.3 1.022e-06 3.3 1.022e-06 3.3 1.029e-06 3.3 1.029e-06 3.3 1.036e-06 3.3 1.036e-06 3.3 1.043e-06 3.3 1.043e-06 3.3 1.05e-06 3.3 1.05e-06 3.3 1.057e-06 3.3 1.057e-06 3.3 1.064e-06 3.3 1.064e-06 3.3 1.071e-06 3.3 1.071e-06 3.3 1.078e-06 3.3 1.078e-06 3.3 1.085e-06 3.3 1.085e-06 3.3 1.092e-06 3.3 1.092e-06 3.3 1.099e-06 3.3 1.099e-06 3.3 1.106e-06 3.3 1.106e-06 3.3 1.113e-06 3.3 1.113e-06 3.3 1.12e-06 3.3 1.12e-06 0 1.127e-06 0 1.127e-06 0 1.134e-06 0 1.134e-06 0 1.141e-06 0 1.141e-06 0 1.148e-06 0 1.148e-06 0 1.155e-06 0 1.155e-06 0 1.162e-06 0 1.162e-06 0 1.169e-06 0 1.169e-06 0 1.176e-06 0 1.176e-06 0 1.183e-06 0 1.183e-06 0 1.19e-06 0 1.19e-06 0 1.197e-06 0 1.197e-06 0 1.204e-06 0 1.204e-06 0 1.211e-06 0 1.211e-06 0 1.218e-06 0 1.218e-06 0 1.225e-06 0 1.225e-06 0 1.232e-06 0 1.232e-06 3.3 1.239e-06 3.3 1.239e-06 3.3 1.246e-06 3.3 1.246e-06 3.3 1.253e-06 3.3 1.253e-06 3.3 1.26e-06 3.3 1.26e-06 3.3 1.267e-06 3.3 1.267e-06 3.3 1.274e-06 3.3 1.274e-06 3.3 1.281e-06 3.3 1.281e-06 3.3 1.288e-06 3.3 1.288e-06 3.3 1.295e-06 3.3 1.295e-06 3.3 1.302e-06 3.3 1.302e-06 3.3 1.309e-06 3.3 1.309e-06 3.3 1.316e-06 3.3 1.316e-06 3.3 1.323e-06 3.3 1.323e-06 3.3 1.33e-06 3.3 1.33e-06 3.3 1.337e-06 3.3 1.337e-06 3.3 1.344e-06 3.3 1.344e-06 0 1.351e-06 0 1.351e-06 0 1.358e-06 0 1.358e-06 0 1.365e-06 0 1.365e-06 0 1.372e-06 0 1.372e-06 0 1.379e-06 0 1.379e-06 0 1.386e-06 0 1.386e-06 0 1.393e-06 0 1.393e-06 0 1.4e-06 0 1.4e-06 0 1.407e-06 0 1.407e-06 0 1.414e-06 0 1.414e-06 0 1.421e-06 0 1.421e-06 0 1.428e-06 0 1.428e-06 0 1.435e-06 0 1.435e-06 0 1.442e-06 0 1.442e-06 0 1.449e-06 0 1.449e-06 0 1.456e-06 0 1.456e-06 3.3 1.463e-06 3.3 1.463e-06 3.3 1.47e-06 3.3 1.47e-06 3.3 1.477e-06 3.3 1.477e-06 3.3 1.484e-06 3.3 1.484e-06 3.3 1.491e-06 3.3 1.491e-06 3.3 1.498e-06 3.3 1.498e-06 3.3 1.505e-06 3.3 1.505e-06 3.3 1.512e-06 3.3 1.512e-06 3.3 1.519e-06 3.3 1.519e-06 3.3 1.526e-06 3.3 1.526e-06 3.3 1.533e-06 3.3 1.533e-06 3.3 1.54e-06 3.3 1.54e-06 3.3 1.547e-06 3.3 1.547e-06 3.3 1.554e-06 3.3 1.554e-06 3.3 1.561e-06 3.3 1.561e-06 3.3 1.568e-06 3.3 1.568e-06 0 1.575e-06 0 1.575e-06 0 1.582e-06 0 1.582e-06 0 1.589e-06 0 1.589e-06 0 1.596e-06 0 1.596e-06 0 1.603e-06 0 1.603e-06 0 1.61e-06 0 1.61e-06 0 1.617e-06 0 1.617e-06 0 1.624e-06 0 1.624e-06 0 1.631e-06 0 1.631e-06 0 1.638e-06 0 1.638e-06 0 1.645e-06 0 1.645e-06 0 1.652e-06 0 1.652e-06 0 1.659e-06 0 1.659e-06 0 1.666e-06 0 1.666e-06 0 1.673e-06 0 1.673e-06 0 1.68e-06 0 1.68e-06 3.3 1.687e-06 3.3 1.687e-06 3.3 1.694e-06 3.3 1.694e-06 3.3 1.701e-06 3.3 1.701e-06 3.3 1.708e-06 3.3 1.708e-06 3.3 1.715e-06 3.3 1.715e-06 3.3 1.722e-06 3.3 1.722e-06 3.3 1.729e-06 3.3 1.729e-06 3.3 1.736e-06 3.3 1.736e-06 3.3 1.743e-06 3.3 1.743e-06 3.3 1.75e-06 3.3 1.75e-06 3.3 1.757e-06 3.3 1.757e-06 3.3 1.764e-06 3.3 1.764e-06 3.3 1.771e-06 3.3 1.771e-06 3.3 1.778e-06 3.3 1.778e-06 3.3 1.785e-06 3.3 1.785e-06 3.3 1.792e-06 3.3 1.792e-06 3.3 1.799e-06 3.3 1.799e-06 3.3 1.806e-06 3.3 1.806e-06 3.3 1.813e-06 3.3 1.813e-06 3.3)
VS1 S1 0 PWL(0 0 7e-09 0 7.05e-09 0 1.4e-08 0 1.405e-08 0 2.1e-08 0 2.105e-08 0 2.8e-08 0 2.805e-08 0 3.5e-08 0 3.505e-08 0 4.2e-08 0 4.205e-08 0 4.9e-08 0 4.905e-08 0 5.6e-08 0 5.605e-08 0 6.3e-08 0 6.305e-08 0 7e-08 0 7.005e-08 0 7.7e-08 0 7.705e-08 0 8.4e-08 0 8.405e-08 0 9.1e-08 0 9.105e-08 0 9.8e-08 0 9.805e-08 0 1.05e-07 0 1.051e-07 0 1.12e-07 0 1.121e-07 0 1.19e-07 0 1.19e-07 0 1.26e-07 0 1.26e-07 0 1.33e-07 0 1.33e-07 0 1.4e-07 0 1.4e-07 0 1.47e-07 0 1.471e-07 0 1.54e-07 0 1.541e-07 0 1.61e-07 0 1.611e-07 0 1.68e-07 0 1.68e-07 0 1.75e-07 0 1.75e-07 0 1.82e-07 0 1.82e-07 0 1.89e-07 0 1.89e-07 0 1.96e-07 0 1.961e-07 0 2.03e-07 0 2.031e-07 0 2.1e-07 0 2.101e-07 0 2.17e-07 0 2.171e-07 0 2.24e-07 0 2.24e-07 3.3 2.31e-07 3.3 2.31e-07 3.3 2.38e-07 3.3 2.38e-07 3.3 2.45e-07 3.3 2.45e-07 3.3 2.52e-07 3.3 2.52e-07 3.3 2.59e-07 3.3 2.59e-07 3.3 2.66e-07 3.3 2.66e-07 3.3 2.73e-07 3.3 2.73e-07 3.3 2.8e-07 3.3 2.8e-07 3.3 2.87e-07 3.3 2.871e-07 3.3 2.94e-07 3.3 2.941e-07 3.3 3.01e-07 3.3 3.011e-07 3.3 3.08e-07 3.3 3.081e-07 3.3 3.15e-07 3.3 3.151e-07 3.3 3.22e-07 3.3 3.221e-07 3.3 3.29e-07 3.3 3.29e-07 3.3 3.36e-07 3.3 3.36e-07 3.3 3.43e-07 3.3 3.43e-07 3.3 3.5e-07 3.3 3.5e-07 3.3 3.57e-07 3.3 3.57e-07 3.3 3.64e-07 3.3 3.64e-07 3.3 3.71e-07 3.3 3.71e-07 3.3 3.78e-07 3.3 3.78e-07 3.3 3.85e-07 3.3 3.85e-07 3.3 3.92e-07 3.3 3.921e-07 3.3 3.99e-07 3.3 3.991e-07 3.3 4.06e-07 3.3 4.061e-07 3.3 4.13e-07 3.3 4.131e-07 3.3 4.2e-07 3.3 4.201e-07 3.3 4.27e-07 3.3 4.271e-07 3.3 4.34e-07 3.3 4.34e-07 3.3 4.41e-07 3.3 4.41e-07 3.3 4.48e-07 3.3 4.48e-07 0 4.55e-07 0 4.55e-07 0 4.62e-07 0 4.62e-07 0 4.69e-07 0 4.69e-07 0 4.76e-07 0 4.76e-07 0 4.83e-07 0 4.83e-07 0 4.9e-07 0 4.9e-07 0 4.97e-07 0 4.97e-07 0 5.04e-07 0 5.04e-07 0 5.11e-07 0 5.11e-07 0 5.18e-07 0 5.18e-07 0 5.25e-07 0 5.25e-07 0 5.32e-07 0 5.32e-07 0 5.39e-07 0 5.39e-07 0 5.46e-07 0 5.46e-07 0 5.53e-07 0 5.53e-07 0 5.6e-07 0 5.6e-07 0 5.67e-07 0 5.671e-07 0 5.74e-07 0 5.741e-07 0 5.81e-07 0 5.811e-07 0 5.88e-07 0 5.881e-07 0 5.95e-07 0 5.951e-07 0 6.02e-07 0 6.021e-07 0 6.09e-07 0 6.091e-07 0 6.16e-07 0 6.161e-07 0 6.23e-07 0 6.231e-07 0 6.3e-07 0 6.301e-07 0 6.37e-07 0 6.371e-07 0 6.44e-07 0 6.441e-07 0 6.51e-07 0 6.51e-07 0 6.58e-07 0 6.58e-07 0 6.65e-07 0 6.65e-07 0 6.72e-07 0 6.72e-07 3.3 6.79e-07 3.3 6.79e-07 3.3 6.86e-07 3.3 6.86e-07 3.3 6.93e-07 3.3 6.93e-07 3.3 7e-07 3.3 7e-07 3.3 7.07e-07 3.3 7.07e-07 3.3 7.14e-07 3.3 7.14e-07 3.3 7.21e-07 3.3 7.21e-07 3.3 7.28e-07 3.3 7.28e-07 3.3 7.35e-07 3.3 7.35e-07 3.3 7.42e-07 3.3 7.42e-07 3.3 7.49e-07 3.3 7.49e-07 3.3 7.56e-07 3.3 7.56e-07 3.3 7.63e-07 3.3 7.63e-07 3.3 7.7e-07 3.3 7.7e-07 3.3 7.77e-07 3.3 7.77e-07 3.3 7.84e-07 3.3 7.841e-07 3.3 7.91e-07 3.3 7.911e-07 3.3 7.98e-07 3.3 7.981e-07 3.3 8.05e-07 3.3 8.051e-07 3.3 8.12e-07 3.3 8.121e-07 3.3 8.19e-07 3.3 8.191e-07 3.3 8.26e-07 3.3 8.261e-07 3.3 8.33e-07 3.3 8.331e-07 3.3 8.4e-07 3.3 8.401e-07 3.3 8.47e-07 3.3 8.471e-07 3.3 8.54e-07 3.3 8.541e-07 3.3 8.61e-07 3.3 8.61e-07 3.3 8.68e-07 3.3 8.68e-07 3.3 8.75e-07 3.3 8.75e-07 3.3 8.82e-07 3.3 8.82e-07 3.3 8.89e-07 3.3 8.89e-07 3.3 8.96e-07 3.3 8.96e-07 0 9.03e-07 0 9.03e-07 0 9.1e-07 0 9.1e-07 0 9.17e-07 0 9.17e-07 0 9.24e-07 0 9.24e-07 0 9.31e-07 0 9.31e-07 0 9.38e-07 0 9.38e-07 0 9.45e-07 0 9.45e-07 0 9.52e-07 0 9.52e-07 0 9.59e-07 0 9.59e-07 0 9.66e-07 0 9.66e-07 0 9.73e-07 0 9.73e-07 0 9.8e-07 0 9.8e-07 0 9.87e-07 0 9.87e-07 0 9.94e-07 0 9.94e-07 0 1.001e-06 0 1.001e-06 0 1.008e-06 0 1.008e-06 0 1.015e-06 0 1.015e-06 0 1.022e-06 0 1.022e-06 0 1.029e-06 0 1.029e-06 0 1.036e-06 0 1.036e-06 0 1.043e-06 0 1.043e-06 0 1.05e-06 0 1.05e-06 0 1.057e-06 0 1.057e-06 0 1.064e-06 0 1.064e-06 0 1.071e-06 0 1.071e-06 0 1.078e-06 0 1.078e-06 0 1.085e-06 0 1.085e-06 0 1.092e-06 0 1.092e-06 0 1.099e-06 0 1.099e-06 0 1.106e-06 0 1.106e-06 0 1.113e-06 0 1.113e-06 0 1.12e-06 0 1.12e-06 3.3 1.127e-06 3.3 1.127e-06 3.3 1.134e-06 3.3 1.134e-06 3.3 1.141e-06 3.3 1.141e-06 3.3 1.148e-06 3.3 1.148e-06 3.3 1.155e-06 3.3 1.155e-06 3.3 1.162e-06 3.3 1.162e-06 3.3 1.169e-06 3.3 1.169e-06 3.3 1.176e-06 3.3 1.176e-06 3.3 1.183e-06 3.3 1.183e-06 3.3 1.19e-06 3.3 1.19e-06 3.3 1.197e-06 3.3 1.197e-06 3.3 1.204e-06 3.3 1.204e-06 3.3 1.211e-06 3.3 1.211e-06 3.3 1.218e-06 3.3 1.218e-06 3.3 1.225e-06 3.3 1.225e-06 3.3 1.232e-06 3.3 1.232e-06 3.3 1.239e-06 3.3 1.239e-06 3.3 1.246e-06 3.3 1.246e-06 3.3 1.253e-06 3.3 1.253e-06 3.3 1.26e-06 3.3 1.26e-06 3.3 1.267e-06 3.3 1.267e-06 3.3 1.274e-06 3.3 1.274e-06 3.3 1.281e-06 3.3 1.281e-06 3.3 1.288e-06 3.3 1.288e-06 3.3 1.295e-06 3.3 1.295e-06 3.3 1.302e-06 3.3 1.302e-06 3.3 1.309e-06 3.3 1.309e-06 3.3 1.316e-06 3.3 1.316e-06 3.3 1.323e-06 3.3 1.323e-06 3.3 1.33e-06 3.3 1.33e-06 3.3 1.337e-06 3.3 1.337e-06 3.3 1.344e-06 3.3 1.344e-06 0 1.351e-06 0 1.351e-06 0 1.358e-06 0 1.358e-06 0 1.365e-06 0 1.365e-06 0 1.372e-06 0 1.372e-06 0 1.379e-06 0 1.379e-06 0 1.386e-06 0 1.386e-06 0 1.393e-06 0 1.393e-06 0 1.4e-06 0 1.4e-06 0 1.407e-06 0 1.407e-06 0 1.414e-06 0 1.414e-06 0 1.421e-06 0 1.421e-06 0 1.428e-06 0 1.428e-06 0 1.435e-06 0 1.435e-06 0 1.442e-06 0 1.442e-06 0 1.449e-06 0 1.449e-06 0 1.456e-06 0 1.456e-06 0 1.463e-06 0 1.463e-06 0 1.47e-06 0 1.47e-06 0 1.477e-06 0 1.477e-06 0 1.484e-06 0 1.484e-06 0 1.491e-06 0 1.491e-06 0 1.498e-06 0 1.498e-06 0 1.505e-06 0 1.505e-06 0 1.512e-06 0 1.512e-06 0 1.519e-06 0 1.519e-06 0 1.526e-06 0 1.526e-06 0 1.533e-06 0 1.533e-06 0 1.54e-06 0 1.54e-06 0 1.547e-06 0 1.547e-06 0 1.554e-06 0 1.554e-06 0 1.561e-06 0 1.561e-06 0 1.568e-06 0 1.568e-06 3.3 1.575e-06 3.3 1.575e-06 3.3 1.582e-06 3.3 1.582e-06 3.3 1.589e-06 3.3 1.589e-06 3.3 1.596e-06 3.3 1.596e-06 3.3 1.603e-06 3.3 1.603e-06 3.3 1.61e-06 3.3 1.61e-06 3.3 1.617e-06 3.3 1.617e-06 3.3 1.624e-06 3.3 1.624e-06 3.3 1.631e-06 3.3 1.631e-06 3.3 1.638e-06 3.3 1.638e-06 3.3 1.645e-06 3.3 1.645e-06 3.3 1.652e-06 3.3 1.652e-06 3.3 1.659e-06 3.3 1.659e-06 3.3 1.666e-06 3.3 1.666e-06 3.3 1.673e-06 3.3 1.673e-06 3.3 1.68e-06 3.3 1.68e-06 3.3 1.687e-06 3.3 1.687e-06 3.3 1.694e-06 3.3 1.694e-06 3.3 1.701e-06 3.3 1.701e-06 3.3 1.708e-06 3.3 1.708e-06 3.3 1.715e-06 3.3 1.715e-06 3.3 1.722e-06 3.3 1.722e-06 3.3 1.729e-06 3.3 1.729e-06 3.3 1.736e-06 3.3 1.736e-06 3.3 1.743e-06 3.3 1.743e-06 3.3 1.75e-06 3.3 1.75e-06 3.3 1.757e-06 3.3 1.757e-06 3.3 1.764e-06 3.3 1.764e-06 3.3 1.771e-06 3.3 1.771e-06 3.3 1.778e-06 3.3 1.778e-06 3.3 1.785e-06 3.3 1.785e-06 3.3 1.792e-06 3.3 1.792e-06 0 1.799e-06 0 1.799e-06 0 1.806e-06 0 1.806e-06 0 1.813e-06 0 1.813e-06 0)
VS2 S2 0 PWL(0 0 7e-09 0 7.05e-09 0 1.4e-08 0 1.405e-08 0 2.1e-08 0 2.105e-08 0 2.8e-08 0 2.805e-08 0 3.5e-08 0 3.505e-08 0 4.2e-08 0 4.205e-08 0 4.9e-08 0 4.905e-08 0 5.6e-08 0 5.605e-08 0 6.3e-08 0 6.305e-08 0 7e-08 0 7.005e-08 0 7.7e-08 0 7.705e-08 0 8.4e-08 0 8.405e-08 0 9.1e-08 0 9.105e-08 0 9.8e-08 0 9.805e-08 0 1.05e-07 0 1.051e-07 0 1.12e-07 0 1.121e-07 0 1.19e-07 0 1.19e-07 0 1.26e-07 0 1.26e-07 0 1.33e-07 0 1.33e-07 0 1.4e-07 0 1.4e-07 0 1.47e-07 0 1.471e-07 0 1.54e-07 0 1.541e-07 0 1.61e-07 0 1.611e-07 0 1.68e-07 0 1.68e-07 0 1.75e-07 0 1.75e-07 0 1.82e-07 0 1.82e-07 0 1.89e-07 0 1.89e-07 0 1.96e-07 0 1.961e-07 0 2.03e-07 0 2.031e-07 0 2.1e-07 0 2.101e-07 0 2.17e-07 0 2.171e-07 0 2.24e-07 0 2.24e-07 0 2.31e-07 0 2.31e-07 0 2.38e-07 0 2.38e-07 0 2.45e-07 0 2.45e-07 0 2.52e-07 0 2.52e-07 0 2.59e-07 0 2.59e-07 0 2.66e-07 0 2.66e-07 0 2.73e-07 0 2.73e-07 0 2.8e-07 0 2.8e-07 0 2.87e-07 0 2.871e-07 0 2.94e-07 0 2.941e-07 0 3.01e-07 0 3.011e-07 0 3.08e-07 0 3.081e-07 0 3.15e-07 0 3.151e-07 0 3.22e-07 0 3.221e-07 0 3.29e-07 0 3.29e-07 0 3.36e-07 0 3.36e-07 0 3.43e-07 0 3.43e-07 0 3.5e-07 0 3.5e-07 0 3.57e-07 0 3.57e-07 0 3.64e-07 0 3.64e-07 0 3.71e-07 0 3.71e-07 0 3.78e-07 0 3.78e-07 0 3.85e-07 0 3.85e-07 0 3.92e-07 0 3.921e-07 0 3.99e-07 0 3.991e-07 0 4.06e-07 0 4.061e-07 0 4.13e-07 0 4.131e-07 0 4.2e-07 0 4.201e-07 0 4.27e-07 0 4.271e-07 0 4.34e-07 0 4.34e-07 0 4.41e-07 0 4.41e-07 0 4.48e-07 0 4.48e-07 3.3 4.55e-07 3.3 4.55e-07 3.3 4.62e-07 3.3 4.62e-07 3.3 4.69e-07 3.3 4.69e-07 3.3 4.76e-07 3.3 4.76e-07 3.3 4.83e-07 3.3 4.83e-07 3.3 4.9e-07 3.3 4.9e-07 3.3 4.97e-07 3.3 4.97e-07 3.3 5.04e-07 3.3 5.04e-07 3.3 5.11e-07 3.3 5.11e-07 3.3 5.18e-07 3.3 5.18e-07 3.3 5.25e-07 3.3 5.25e-07 3.3 5.32e-07 3.3 5.32e-07 3.3 5.39e-07 3.3 5.39e-07 3.3 5.46e-07 3.3 5.46e-07 3.3 5.53e-07 3.3 5.53e-07 3.3 5.6e-07 3.3 5.6e-07 3.3 5.67e-07 3.3 5.671e-07 3.3 5.74e-07 3.3 5.741e-07 3.3 5.81e-07 3.3 5.811e-07 3.3 5.88e-07 3.3 5.881e-07 3.3 5.95e-07 3.3 5.951e-07 3.3 6.02e-07 3.3 6.021e-07 3.3 6.09e-07 3.3 6.091e-07 3.3 6.16e-07 3.3 6.161e-07 3.3 6.23e-07 3.3 6.231e-07 3.3 6.3e-07 3.3 6.301e-07 3.3 6.37e-07 3.3 6.371e-07 3.3 6.44e-07 3.3 6.441e-07 3.3 6.51e-07 3.3 6.51e-07 3.3 6.58e-07 3.3 6.58e-07 3.3 6.65e-07 3.3 6.65e-07 3.3 6.72e-07 3.3 6.72e-07 3.3 6.79e-07 3.3 6.79e-07 3.3 6.86e-07 3.3 6.86e-07 3.3 6.93e-07 3.3 6.93e-07 3.3 7e-07 3.3 7e-07 3.3 7.07e-07 3.3 7.07e-07 3.3 7.14e-07 3.3 7.14e-07 3.3 7.21e-07 3.3 7.21e-07 3.3 7.28e-07 3.3 7.28e-07 3.3 7.35e-07 3.3 7.35e-07 3.3 7.42e-07 3.3 7.42e-07 3.3 7.49e-07 3.3 7.49e-07 3.3 7.56e-07 3.3 7.56e-07 3.3 7.63e-07 3.3 7.63e-07 3.3 7.7e-07 3.3 7.7e-07 3.3 7.77e-07 3.3 7.77e-07 3.3 7.84e-07 3.3 7.841e-07 3.3 7.91e-07 3.3 7.911e-07 3.3 7.98e-07 3.3 7.981e-07 3.3 8.05e-07 3.3 8.051e-07 3.3 8.12e-07 3.3 8.121e-07 3.3 8.19e-07 3.3 8.191e-07 3.3 8.26e-07 3.3 8.261e-07 3.3 8.33e-07 3.3 8.331e-07 3.3 8.4e-07 3.3 8.401e-07 3.3 8.47e-07 3.3 8.471e-07 3.3 8.54e-07 3.3 8.541e-07 3.3 8.61e-07 3.3 8.61e-07 3.3 8.68e-07 3.3 8.68e-07 3.3 8.75e-07 3.3 8.75e-07 3.3 8.82e-07 3.3 8.82e-07 3.3 8.89e-07 3.3 8.89e-07 3.3 8.96e-07 3.3 8.96e-07 0 9.03e-07 0 9.03e-07 0 9.1e-07 0 9.1e-07 0 9.17e-07 0 9.17e-07 0 9.24e-07 0 9.24e-07 0 9.31e-07 0 9.31e-07 0 9.38e-07 0 9.38e-07 0 9.45e-07 0 9.45e-07 0 9.52e-07 0 9.52e-07 0 9.59e-07 0 9.59e-07 0 9.66e-07 0 9.66e-07 0 9.73e-07 0 9.73e-07 0 9.8e-07 0 9.8e-07 0 9.87e-07 0 9.87e-07 0 9.94e-07 0 9.94e-07 0 1.001e-06 0 1.001e-06 0 1.008e-06 0 1.008e-06 0 1.015e-06 0 1.015e-06 0 1.022e-06 0 1.022e-06 0 1.029e-06 0 1.029e-06 0 1.036e-06 0 1.036e-06 0 1.043e-06 0 1.043e-06 0 1.05e-06 0 1.05e-06 0 1.057e-06 0 1.057e-06 0 1.064e-06 0 1.064e-06 0 1.071e-06 0 1.071e-06 0 1.078e-06 0 1.078e-06 0 1.085e-06 0 1.085e-06 0 1.092e-06 0 1.092e-06 0 1.099e-06 0 1.099e-06 0 1.106e-06 0 1.106e-06 0 1.113e-06 0 1.113e-06 0 1.12e-06 0 1.12e-06 0 1.127e-06 0 1.127e-06 0 1.134e-06 0 1.134e-06 0 1.141e-06 0 1.141e-06 0 1.148e-06 0 1.148e-06 0 1.155e-06 0 1.155e-06 0 1.162e-06 0 1.162e-06 0 1.169e-06 0 1.169e-06 0 1.176e-06 0 1.176e-06 0 1.183e-06 0 1.183e-06 0 1.19e-06 0 1.19e-06 0 1.197e-06 0 1.197e-06 0 1.204e-06 0 1.204e-06 0 1.211e-06 0 1.211e-06 0 1.218e-06 0 1.218e-06 0 1.225e-06 0 1.225e-06 0 1.232e-06 0 1.232e-06 0 1.239e-06 0 1.239e-06 0 1.246e-06 0 1.246e-06 0 1.253e-06 0 1.253e-06 0 1.26e-06 0 1.26e-06 0 1.267e-06 0 1.267e-06 0 1.274e-06 0 1.274e-06 0 1.281e-06 0 1.281e-06 0 1.288e-06 0 1.288e-06 0 1.295e-06 0 1.295e-06 0 1.302e-06 0 1.302e-06 0 1.309e-06 0 1.309e-06 0 1.316e-06 0 1.316e-06 0 1.323e-06 0 1.323e-06 0 1.33e-06 0 1.33e-06 0 1.337e-06 0 1.337e-06 0 1.344e-06 0 1.344e-06 3.3 1.351e-06 3.3 1.351e-06 3.3 1.358e-06 3.3 1.358e-06 3.3 1.365e-06 3.3 1.365e-06 3.3 1.372e-06 3.3 1.372e-06 3.3 1.379e-06 3.3 1.379e-06 3.3 1.386e-06 3.3 1.386e-06 3.3 1.393e-06 3.3 1.393e-06 3.3 1.4e-06 3.3 1.4e-06 3.3 1.407e-06 3.3 1.407e-06 3.3 1.414e-06 3.3 1.414e-06 3.3 1.421e-06 3.3 1.421e-06 3.3 1.428e-06 3.3 1.428e-06 3.3 1.435e-06 3.3 1.435e-06 3.3 1.442e-06 3.3 1.442e-06 3.3 1.449e-06 3.3 1.449e-06 3.3 1.456e-06 3.3 1.456e-06 3.3 1.463e-06 3.3 1.463e-06 3.3 1.47e-06 3.3 1.47e-06 3.3 1.477e-06 3.3 1.477e-06 3.3 1.484e-06 3.3 1.484e-06 3.3 1.491e-06 3.3 1.491e-06 3.3 1.498e-06 3.3 1.498e-06 3.3 1.505e-06 3.3 1.505e-06 3.3 1.512e-06 3.3 1.512e-06 3.3 1.519e-06 3.3 1.519e-06 3.3 1.526e-06 3.3 1.526e-06 3.3 1.533e-06 3.3 1.533e-06 3.3 1.54e-06 3.3 1.54e-06 3.3 1.547e-06 3.3 1.547e-06 3.3 1.554e-06 3.3 1.554e-06 3.3 1.561e-06 3.3 1.561e-06 3.3 1.568e-06 3.3 1.568e-06 3.3 1.575e-06 3.3 1.575e-06 3.3 1.582e-06 3.3 1.582e-06 3.3 1.589e-06 3.3 1.589e-06 3.3 1.596e-06 3.3 1.596e-06 3.3 1.603e-06 3.3 1.603e-06 3.3 1.61e-06 3.3 1.61e-06 3.3 1.617e-06 3.3 1.617e-06 3.3 1.624e-06 3.3 1.624e-06 3.3 1.631e-06 3.3 1.631e-06 3.3 1.638e-06 3.3 1.638e-06 3.3 1.645e-06 3.3 1.645e-06 3.3 1.652e-06 3.3 1.652e-06 3.3 1.659e-06 3.3 1.659e-06 3.3 1.666e-06 3.3 1.666e-06 3.3 1.673e-06 3.3 1.673e-06 3.3 1.68e-06 3.3 1.68e-06 3.3 1.687e-06 3.3 1.687e-06 3.3 1.694e-06 3.3 1.694e-06 3.3 1.701e-06 3.3 1.701e-06 3.3 1.708e-06 3.3 1.708e-06 3.3 1.715e-06 3.3 1.715e-06 3.3 1.722e-06 3.3 1.722e-06 3.3 1.729e-06 3.3 1.729e-06 3.3 1.736e-06 3.3 1.736e-06 3.3 1.743e-06 3.3 1.743e-06 3.3 1.75e-06 3.3 1.75e-06 3.3 1.757e-06 3.3 1.757e-06 3.3 1.764e-06 3.3 1.764e-06 3.3 1.771e-06 3.3 1.771e-06 3.3 1.778e-06 3.3 1.778e-06 3.3 1.785e-06 3.3 1.785e-06 3.3 1.792e-06 3.3 1.792e-06 0 1.799e-06 0 1.799e-06 0 1.806e-06 0 1.806e-06 0 1.813e-06 0 1.813e-06 0)
VS3 S3 0 PWL(0 0 7e-09 0 7.05e-09 0 1.4e-08 0 1.405e-08 0 2.1e-08 0 2.105e-08 0 2.8e-08 0 2.805e-08 0 3.5e-08 0 3.505e-08 0 4.2e-08 0 4.205e-08 0 4.9e-08 0 4.905e-08 0 5.6e-08 0 5.605e-08 0 6.3e-08 0 6.305e-08 0 7e-08 0 7.005e-08 0 7.7e-08 0 7.705e-08 0 8.4e-08 0 8.405e-08 0 9.1e-08 0 9.105e-08 0 9.8e-08 0 9.805e-08 0 1.05e-07 0 1.051e-07 0 1.12e-07 0 1.121e-07 0 1.19e-07 0 1.19e-07 0 1.26e-07 0 1.26e-07 0 1.33e-07 0 1.33e-07 0 1.4e-07 0 1.4e-07 0 1.47e-07 0 1.471e-07 0 1.54e-07 0 1.541e-07 0 1.61e-07 0 1.611e-07 0 1.68e-07 0 1.68e-07 0 1.75e-07 0 1.75e-07 0 1.82e-07 0 1.82e-07 0 1.89e-07 0 1.89e-07 0 1.96e-07 0 1.961e-07 0 2.03e-07 0 2.031e-07 0 2.1e-07 0 2.101e-07 0 2.17e-07 0 2.171e-07 0 2.24e-07 0 2.24e-07 0 2.31e-07 0 2.31e-07 0 2.38e-07 0 2.38e-07 0 2.45e-07 0 2.45e-07 0 2.52e-07 0 2.52e-07 0 2.59e-07 0 2.59e-07 0 2.66e-07 0 2.66e-07 0 2.73e-07 0 2.73e-07 0 2.8e-07 0 2.8e-07 0 2.87e-07 0 2.871e-07 0 2.94e-07 0 2.941e-07 0 3.01e-07 0 3.011e-07 0 3.08e-07 0 3.081e-07 0 3.15e-07 0 3.151e-07 0 3.22e-07 0 3.221e-07 0 3.29e-07 0 3.29e-07 0 3.36e-07 0 3.36e-07 0 3.43e-07 0 3.43e-07 0 3.5e-07 0 3.5e-07 0 3.57e-07 0 3.57e-07 0 3.64e-07 0 3.64e-07 0 3.71e-07 0 3.71e-07 0 3.78e-07 0 3.78e-07 0 3.85e-07 0 3.85e-07 0 3.92e-07 0 3.921e-07 0 3.99e-07 0 3.991e-07 0 4.06e-07 0 4.061e-07 0 4.13e-07 0 4.131e-07 0 4.2e-07 0 4.201e-07 0 4.27e-07 0 4.271e-07 0 4.34e-07 0 4.34e-07 0 4.41e-07 0 4.41e-07 0 4.48e-07 0 4.48e-07 0 4.55e-07 0 4.55e-07 0 4.62e-07 0 4.62e-07 0 4.69e-07 0 4.69e-07 0 4.76e-07 0 4.76e-07 0 4.83e-07 0 4.83e-07 0 4.9e-07 0 4.9e-07 0 4.97e-07 0 4.97e-07 0 5.04e-07 0 5.04e-07 0 5.11e-07 0 5.11e-07 0 5.18e-07 0 5.18e-07 0 5.25e-07 0 5.25e-07 0 5.32e-07 0 5.32e-07 0 5.39e-07 0 5.39e-07 0 5.46e-07 0 5.46e-07 0 5.53e-07 0 5.53e-07 0 5.6e-07 0 5.6e-07 0 5.67e-07 0 5.671e-07 0 5.74e-07 0 5.741e-07 0 5.81e-07 0 5.811e-07 0 5.88e-07 0 5.881e-07 0 5.95e-07 0 5.951e-07 0 6.02e-07 0 6.021e-07 0 6.09e-07 0 6.091e-07 0 6.16e-07 0 6.161e-07 0 6.23e-07 0 6.231e-07 0 6.3e-07 0 6.301e-07 0 6.37e-07 0 6.371e-07 0 6.44e-07 0 6.441e-07 0 6.51e-07 0 6.51e-07 0 6.58e-07 0 6.58e-07 0 6.65e-07 0 6.65e-07 0 6.72e-07 0 6.72e-07 0 6.79e-07 0 6.79e-07 0 6.86e-07 0 6.86e-07 0 6.93e-07 0 6.93e-07 0 7e-07 0 7e-07 0 7.07e-07 0 7.07e-07 0 7.14e-07 0 7.14e-07 0 7.21e-07 0 7.21e-07 0 7.28e-07 0 7.28e-07 0 7.35e-07 0 7.35e-07 0 7.42e-07 0 7.42e-07 0 7.49e-07 0 7.49e-07 0 7.56e-07 0 7.56e-07 0 7.63e-07 0 7.63e-07 0 7.7e-07 0 7.7e-07 0 7.77e-07 0 7.77e-07 0 7.84e-07 0 7.841e-07 0 7.91e-07 0 7.911e-07 0 7.98e-07 0 7.981e-07 0 8.05e-07 0 8.051e-07 0 8.12e-07 0 8.121e-07 0 8.19e-07 0 8.191e-07 0 8.26e-07 0 8.261e-07 0 8.33e-07 0 8.331e-07 0 8.4e-07 0 8.401e-07 0 8.47e-07 0 8.471e-07 0 8.54e-07 0 8.541e-07 0 8.61e-07 0 8.61e-07 0 8.68e-07 0 8.68e-07 0 8.75e-07 0 8.75e-07 0 8.82e-07 0 8.82e-07 0 8.89e-07 0 8.89e-07 0 8.96e-07 0 8.96e-07 3.3 9.03e-07 3.3 9.03e-07 3.3 9.1e-07 3.3 9.1e-07 3.3 9.17e-07 3.3 9.17e-07 3.3 9.24e-07 3.3 9.24e-07 3.3 9.31e-07 3.3 9.31e-07 3.3 9.38e-07 3.3 9.38e-07 3.3 9.45e-07 3.3 9.45e-07 3.3 9.52e-07 3.3 9.52e-07 3.3 9.59e-07 3.3 9.59e-07 3.3 9.66e-07 3.3 9.66e-07 3.3 9.73e-07 3.3 9.73e-07 3.3 9.8e-07 3.3 9.8e-07 3.3 9.87e-07 3.3 9.87e-07 3.3 9.94e-07 3.3 9.94e-07 3.3 1.001e-06 3.3 1.001e-06 3.3 1.008e-06 3.3 1.008e-06 3.3 1.015e-06 3.3 1.015e-06 3.3 1.022e-06 3.3 1.022e-06 3.3 1.029e-06 3.3 1.029e-06 3.3 1.036e-06 3.3 1.036e-06 3.3 1.043e-06 3.3 1.043e-06 3.3 1.05e-06 3.3 1.05e-06 3.3 1.057e-06 3.3 1.057e-06 3.3 1.064e-06 3.3 1.064e-06 3.3 1.071e-06 3.3 1.071e-06 3.3 1.078e-06 3.3 1.078e-06 3.3 1.085e-06 3.3 1.085e-06 3.3 1.092e-06 3.3 1.092e-06 3.3 1.099e-06 3.3 1.099e-06 3.3 1.106e-06 3.3 1.106e-06 3.3 1.113e-06 3.3 1.113e-06 3.3 1.12e-06 3.3 1.12e-06 3.3 1.127e-06 3.3 1.127e-06 3.3 1.134e-06 3.3 1.134e-06 3.3 1.141e-06 3.3 1.141e-06 3.3 1.148e-06 3.3 1.148e-06 3.3 1.155e-06 3.3 1.155e-06 3.3 1.162e-06 3.3 1.162e-06 3.3 1.169e-06 3.3 1.169e-06 3.3 1.176e-06 3.3 1.176e-06 3.3 1.183e-06 3.3 1.183e-06 3.3 1.19e-06 3.3 1.19e-06 3.3 1.197e-06 3.3 1.197e-06 3.3 1.204e-06 3.3 1.204e-06 3.3 1.211e-06 3.3 1.211e-06 3.3 1.218e-06 3.3 1.218e-06 3.3 1.225e-06 3.3 1.225e-06 3.3 1.232e-06 3.3 1.232e-06 3.3 1.239e-06 3.3 1.239e-06 3.3 1.246e-06 3.3 1.246e-06 3.3 1.253e-06 3.3 1.253e-06 3.3 1.26e-06 3.3 1.26e-06 3.3 1.267e-06 3.3 1.267e-06 3.3 1.274e-06 3.3 1.274e-06 3.3 1.281e-06 3.3 1.281e-06 3.3 1.288e-06 3.3 1.288e-06 3.3 1.295e-06 3.3 1.295e-06 3.3 1.302e-06 3.3 1.302e-06 3.3 1.309e-06 3.3 1.309e-06 3.3 1.316e-06 3.3 1.316e-06 3.3 1.323e-06 3.3 1.323e-06 3.3 1.33e-06 3.3 1.33e-06 3.3 1.337e-06 3.3 1.337e-06 3.3 1.344e-06 3.3 1.344e-06 3.3 1.351e-06 3.3 1.351e-06 3.3 1.358e-06 3.3 1.358e-06 3.3 1.365e-06 3.3 1.365e-06 3.3 1.372e-06 3.3 1.372e-06 3.3 1.379e-06 3.3 1.379e-06 3.3 1.386e-06 3.3 1.386e-06 3.3 1.393e-06 3.3 1.393e-06 3.3 1.4e-06 3.3 1.4e-06 3.3 1.407e-06 3.3 1.407e-06 3.3 1.414e-06 3.3 1.414e-06 3.3 1.421e-06 3.3 1.421e-06 3.3 1.428e-06 3.3 1.428e-06 3.3 1.435e-06 3.3 1.435e-06 3.3 1.442e-06 3.3 1.442e-06 3.3 1.449e-06 3.3 1.449e-06 3.3 1.456e-06 3.3 1.456e-06 3.3 1.463e-06 3.3 1.463e-06 3.3 1.47e-06 3.3 1.47e-06 3.3 1.477e-06 3.3 1.477e-06 3.3 1.484e-06 3.3 1.484e-06 3.3 1.491e-06 3.3 1.491e-06 3.3 1.498e-06 3.3 1.498e-06 3.3 1.505e-06 3.3 1.505e-06 3.3 1.512e-06 3.3 1.512e-06 3.3 1.519e-06 3.3 1.519e-06 3.3 1.526e-06 3.3 1.526e-06 3.3 1.533e-06 3.3 1.533e-06 3.3 1.54e-06 3.3 1.54e-06 3.3 1.547e-06 3.3 1.547e-06 3.3 1.554e-06 3.3 1.554e-06 3.3 1.561e-06 3.3 1.561e-06 3.3 1.568e-06 3.3 1.568e-06 3.3 1.575e-06 3.3 1.575e-06 3.3 1.582e-06 3.3 1.582e-06 3.3 1.589e-06 3.3 1.589e-06 3.3 1.596e-06 3.3 1.596e-06 3.3 1.603e-06 3.3 1.603e-06 3.3 1.61e-06 3.3 1.61e-06 3.3 1.617e-06 3.3 1.617e-06 3.3 1.624e-06 3.3 1.624e-06 3.3 1.631e-06 3.3 1.631e-06 3.3 1.638e-06 3.3 1.638e-06 3.3 1.645e-06 3.3 1.645e-06 3.3 1.652e-06 3.3 1.652e-06 3.3 1.659e-06 3.3 1.659e-06 3.3 1.666e-06 3.3 1.666e-06 3.3 1.673e-06 3.3 1.673e-06 3.3 1.68e-06 3.3 1.68e-06 3.3 1.687e-06 3.3 1.687e-06 3.3 1.694e-06 3.3 1.694e-06 3.3 1.701e-06 3.3 1.701e-06 3.3 1.708e-06 3.3 1.708e-06 3.3 1.715e-06 3.3 1.715e-06 3.3 1.722e-06 3.3 1.722e-06 3.3 1.729e-06 3.3 1.729e-06 3.3 1.736e-06 3.3 1.736e-06 3.3 1.743e-06 3.3 1.743e-06 3.3 1.75e-06 3.3 1.75e-06 3.3 1.757e-06 3.3 1.757e-06 3.3 1.764e-06 3.3 1.764e-06 3.3 1.771e-06 3.3 1.771e-06 3.3 1.778e-06 3.3 1.778e-06 3.3 1.785e-06 3.3 1.785e-06 3.3 1.792e-06 3.3 1.792e-06 3.3 1.799e-06 3.3 1.799e-06 3.3 1.806e-06 3.3 1.806e-06 3.3 1.813e-06 3.3 1.813e-06 3.3)
VM M 0 PWL(0 0 7e-09 0 7.05e-09 0 1.4e-08 0 1.405e-08 0 2.1e-08 0 2.105e-08 0 2.8e-08 0 2.805e-08 0 3.5e-08 0 3.505e-08 0 4.2e-08 0 4.205e-08 0 4.9e-08 0 4.905e-08 0 5.6e-08 0 5.605e-08 3.3 6.3e-08 3.3 6.305e-08 3.3 7e-08 3.3 7.005e-08 3.3 7.7e-08 3.3 7.705e-08 3.3 8.4e-08 3.3 8.405e-08 3.3 9.1e-08 3.3 9.105e-08 3.3 9.8e-08 3.3 9.805e-08 3.3 1.05e-07 3.3 1.051e-07 3.3 1.12e-07 3.3 1.121e-07 0 1.19e-07 0 1.19e-07 0 1.26e-07 0 1.26e-07 0 1.33e-07 0 1.33e-07 0 1.4e-07 0 1.4e-07 0 1.47e-07 0 1.471e-07 0 1.54e-07 0 1.541e-07 0 1.61e-07 0 1.611e-07 0 1.68e-07 0 1.68e-07 3.3 1.75e-07 3.3 1.75e-07 3.3 1.82e-07 3.3 1.82e-07 3.3 1.89e-07 3.3 1.89e-07 3.3 1.96e-07 3.3 1.961e-07 3.3 2.03e-07 3.3 2.031e-07 3.3 2.1e-07 3.3 2.101e-07 3.3 2.17e-07 3.3 2.171e-07 3.3 2.24e-07 3.3 2.24e-07 0 2.31e-07 0 2.31e-07 0 2.38e-07 0 2.38e-07 0 2.45e-07 0 2.45e-07 0 2.52e-07 0 2.52e-07 0 2.59e-07 0 2.59e-07 0 2.66e-07 0 2.66e-07 0 2.73e-07 0 2.73e-07 0 2.8e-07 0 2.8e-07 3.3 2.87e-07 3.3 2.871e-07 3.3 2.94e-07 3.3 2.941e-07 3.3 3.01e-07 3.3 3.011e-07 3.3 3.08e-07 3.3 3.081e-07 3.3 3.15e-07 3.3 3.151e-07 3.3 3.22e-07 3.3 3.221e-07 3.3 3.29e-07 3.3 3.29e-07 3.3 3.36e-07 3.3 3.36e-07 0 3.43e-07 0 3.43e-07 0 3.5e-07 0 3.5e-07 0 3.57e-07 0 3.57e-07 0 3.64e-07 0 3.64e-07 0 3.71e-07 0 3.71e-07 0 3.78e-07 0 3.78e-07 0 3.85e-07 0 3.85e-07 0 3.92e-07 0 3.921e-07 3.3 3.99e-07 3.3 3.991e-07 3.3 4.06e-07 3.3 4.061e-07 3.3 4.13e-07 3.3 4.131e-07 3.3 4.2e-07 3.3 4.201e-07 3.3 4.27e-07 3.3 4.271e-07 3.3 4.34e-07 3.3 4.34e-07 3.3 4.41e-07 3.3 4.41e-07 3.3 4.48e-07 3.3 4.48e-07 0 4.55e-07 0 4.55e-07 0 4.62e-07 0 4.62e-07 0 4.69e-07 0 4.69e-07 0 4.76e-07 0 4.76e-07 0 4.83e-07 0 4.83e-07 0 4.9e-07 0 4.9e-07 0 4.97e-07 0 4.97e-07 0 5.04e-07 0 5.04e-07 3.3 5.11e-07 3.3 5.11e-07 3.3 5.18e-07 3.3 5.18e-07 3.3 5.25e-07 3.3 5.25e-07 3.3 5.32e-07 3.3 5.32e-07 3.3 5.39e-07 3.3 5.39e-07 3.3 5.46e-07 3.3 5.46e-07 3.3 5.53e-07 3.3 5.53e-07 3.3 5.6e-07 3.3 5.6e-07 0 5.67e-07 0 5.671e-07 0 5.74e-07 0 5.741e-07 0 5.81e-07 0 5.811e-07 0 5.88e-07 0 5.881e-07 0 5.95e-07 0 5.951e-07 0 6.02e-07 0 6.021e-07 0 6.09e-07 0 6.091e-07 0 6.16e-07 0 6.161e-07 3.3 6.23e-07 3.3 6.231e-07 3.3 6.3e-07 3.3 6.301e-07 3.3 6.37e-07 3.3 6.371e-07 3.3 6.44e-07 3.3 6.441e-07 3.3 6.51e-07 3.3 6.51e-07 3.3 6.58e-07 3.3 6.58e-07 3.3 6.65e-07 3.3 6.65e-07 3.3 6.72e-07 3.3 6.72e-07 0 6.79e-07 0 6.79e-07 0 6.86e-07 0 6.86e-07 0 6.93e-07 0 6.93e-07 0 7e-07 0 7e-07 0 7.07e-07 0 7.07e-07 0 7.14e-07 0 7.14e-07 0 7.21e-07 0 7.21e-07 0 7.28e-07 0 7.28e-07 3.3 7.35e-07 3.3 7.35e-07 3.3 7.42e-07 3.3 7.42e-07 3.3 7.49e-07 3.3 7.49e-07 3.3 7.56e-07 3.3 7.56e-07 3.3 7.63e-07 3.3 7.63e-07 3.3 7.7e-07 3.3 7.7e-07 3.3 7.77e-07 3.3 7.77e-07 3.3 7.84e-07 3.3 7.841e-07 0 7.91e-07 0 7.911e-07 0 7.98e-07 0 7.981e-07 0 8.05e-07 0 8.051e-07 0 8.12e-07 0 8.121e-07 0 8.19e-07 0 8.191e-07 0 8.26e-07 0 8.261e-07 0 8.33e-07 0 8.331e-07 0 8.4e-07 0 8.401e-07 3.3 8.47e-07 3.3 8.471e-07 3.3 8.54e-07 3.3 8.541e-07 3.3 8.61e-07 3.3 8.61e-07 3.3 8.68e-07 3.3 8.68e-07 3.3 8.75e-07 3.3 8.75e-07 3.3 8.82e-07 3.3 8.82e-07 3.3 8.89e-07 3.3 8.89e-07 3.3 8.96e-07 3.3 8.96e-07 0 9.03e-07 0 9.03e-07 0 9.1e-07 0 9.1e-07 0 9.17e-07 0 9.17e-07 0 9.24e-07 0 9.24e-07 0 9.31e-07 0 9.31e-07 0 9.38e-07 0 9.38e-07 0 9.45e-07 0 9.45e-07 0 9.52e-07 0 9.52e-07 3.3 9.59e-07 3.3 9.59e-07 3.3 9.66e-07 3.3 9.66e-07 3.3 9.73e-07 3.3 9.73e-07 3.3 9.8e-07 3.3 9.8e-07 3.3 9.87e-07 3.3 9.87e-07 3.3 9.94e-07 3.3 9.94e-07 3.3 1.001e-06 3.3 1.001e-06 3.3 1.008e-06 3.3 1.008e-06 0 1.015e-06 0 1.015e-06 0 1.022e-06 0 1.022e-06 0 1.029e-06 0 1.029e-06 0 1.036e-06 0 1.036e-06 0 1.043e-06 0 1.043e-06 0 1.05e-06 0 1.05e-06 0 1.057e-06 0 1.057e-06 0 1.064e-06 0 1.064e-06 3.3 1.071e-06 3.3 1.071e-06 3.3 1.078e-06 3.3 1.078e-06 3.3 1.085e-06 3.3 1.085e-06 3.3 1.092e-06 3.3 1.092e-06 3.3 1.099e-06 3.3 1.099e-06 3.3 1.106e-06 3.3 1.106e-06 3.3 1.113e-06 3.3 1.113e-06 3.3 1.12e-06 3.3 1.12e-06 0 1.127e-06 0 1.127e-06 0 1.134e-06 0 1.134e-06 0 1.141e-06 0 1.141e-06 0 1.148e-06 0 1.148e-06 0 1.155e-06 0 1.155e-06 0 1.162e-06 0 1.162e-06 0 1.169e-06 0 1.169e-06 0 1.176e-06 0 1.176e-06 3.3 1.183e-06 3.3 1.183e-06 3.3 1.19e-06 3.3 1.19e-06 3.3 1.197e-06 3.3 1.197e-06 3.3 1.204e-06 3.3 1.204e-06 3.3 1.211e-06 3.3 1.211e-06 3.3 1.218e-06 3.3 1.218e-06 3.3 1.225e-06 3.3 1.225e-06 3.3 1.232e-06 3.3 1.232e-06 0 1.239e-06 0 1.239e-06 0 1.246e-06 0 1.246e-06 0 1.253e-06 0 1.253e-06 0 1.26e-06 0 1.26e-06 0 1.267e-06 0 1.267e-06 0 1.274e-06 0 1.274e-06 0 1.281e-06 0 1.281e-06 0 1.288e-06 0 1.288e-06 3.3 1.295e-06 3.3 1.295e-06 3.3 1.302e-06 3.3 1.302e-06 3.3 1.309e-06 3.3 1.309e-06 3.3 1.316e-06 3.3 1.316e-06 3.3 1.323e-06 3.3 1.323e-06 3.3 1.33e-06 3.3 1.33e-06 3.3 1.337e-06 3.3 1.337e-06 3.3 1.344e-06 3.3 1.344e-06 0 1.351e-06 0 1.351e-06 0 1.358e-06 0 1.358e-06 0 1.365e-06 0 1.365e-06 0 1.372e-06 0 1.372e-06 0 1.379e-06 0 1.379e-06 0 1.386e-06 0 1.386e-06 0 1.393e-06 0 1.393e-06 0 1.4e-06 0 1.4e-06 3.3 1.407e-06 3.3 1.407e-06 3.3 1.414e-06 3.3 1.414e-06 3.3 1.421e-06 3.3 1.421e-06 3.3 1.428e-06 3.3 1.428e-06 3.3 1.435e-06 3.3 1.435e-06 3.3 1.442e-06 3.3 1.442e-06 3.3 1.449e-06 3.3 1.449e-06 3.3 1.456e-06 3.3 1.456e-06 0 1.463e-06 0 1.463e-06 0 1.47e-06 0 1.47e-06 0 1.477e-06 0 1.477e-06 0 1.484e-06 0 1.484e-06 0 1.491e-06 0 1.491e-06 0 1.498e-06 0 1.498e-06 0 1.505e-06 0 1.505e-06 0 1.512e-06 0 1.512e-06 3.3 1.519e-06 3.3 1.519e-06 3.3 1.526e-06 3.3 1.526e-06 3.3 1.533e-06 3.3 1.533e-06 3.3 1.54e-06 3.3 1.54e-06 3.3 1.547e-06 3.3 1.547e-06 3.3 1.554e-06 3.3 1.554e-06 3.3 1.561e-06 3.3 1.561e-06 3.3 1.568e-06 3.3 1.568e-06 0 1.575e-06 0 1.575e-06 0 1.582e-06 0 1.582e-06 0 1.589e-06 0 1.589e-06 0 1.596e-06 0 1.596e-06 0 1.603e-06 0 1.603e-06 0 1.61e-06 0 1.61e-06 0 1.617e-06 0 1.617e-06 0 1.624e-06 0 1.624e-06 3.3 1.631e-06 3.3 1.631e-06 3.3 1.638e-06 3.3 1.638e-06 3.3 1.645e-06 3.3 1.645e-06 3.3 1.652e-06 3.3 1.652e-06 3.3 1.659e-06 3.3 1.659e-06 3.3 1.666e-06 3.3 1.666e-06 3.3 1.673e-06 3.3 1.673e-06 3.3 1.68e-06 3.3 1.68e-06 0 1.687e-06 0 1.687e-06 0 1.694e-06 0 1.694e-06 0 1.701e-06 0 1.701e-06 0 1.708e-06 0 1.708e-06 0 1.715e-06 0 1.715e-06 0 1.722e-06 0 1.722e-06 0 1.729e-06 0 1.729e-06 0 1.736e-06 0 1.736e-06 3.3 1.743e-06 3.3 1.743e-06 3.3 1.75e-06 3.3 1.75e-06 3.3 1.757e-06 3.3 1.757e-06 3.3 1.764e-06 3.3 1.764e-06 3.3 1.771e-06 3.3 1.771e-06 3.3 1.778e-06 3.3 1.778e-06 3.3 1.785e-06 3.3 1.785e-06 3.3 1.792e-06 3.3 1.792e-06 0 1.799e-06 0 1.799e-06 0 1.806e-06 0 1.806e-06 0 1.813e-06 0 1.813e-06 0)
VCn Cn 0 PWL(0 3.3 7e-09 3.3 7.05e-09 3.3 1.4e-08 3.3 1.405e-08 3.3 2.1e-08 3.3 2.105e-08 3.3 2.8e-08 3.3 2.805e-08 0 3.5e-08 0 3.505e-08 0 4.2e-08 0 4.205e-08 0 4.9e-08 0 4.905e-08 0 5.6e-08 0 5.605e-08 3.3 6.3e-08 3.3 6.305e-08 3.3 7e-08 3.3 7.005e-08 3.3 7.7e-08 3.3 7.705e-08 3.3 8.4e-08 3.3 8.405e-08 0 9.1e-08 0 9.105e-08 0 9.8e-08 0 9.805e-08 0 1.05e-07 0 1.051e-07 0 1.12e-07 0 1.121e-07 3.3 1.19e-07 3.3 1.19e-07 3.3 1.26e-07 3.3 1.26e-07 3.3 1.33e-07 3.3 1.33e-07 3.3 1.4e-07 3.3 1.4e-07 0 1.47e-07 0 1.471e-07 0 1.54e-07 0 1.541e-07 0 1.61e-07 0 1.611e-07 0 1.68e-07 0 1.68e-07 3.3 1.75e-07 3.3 1.75e-07 3.3 1.82e-07 3.3 1.82e-07 3.3 1.89e-07 3.3 1.89e-07 3.3 1.96e-07 3.3 1.961e-07 0 2.03e-07 0 2.031e-07 0 2.1e-07 0 2.101e-07 0 2.17e-07 0 2.171e-07 0 2.24e-07 0 2.24e-07 3.3 2.31e-07 3.3 2.31e-07 3.3 2.38e-07 3.3 2.38e-07 3.3 2.45e-07 3.3 2.45e-07 3.3 2.52e-07 3.3 2.52e-07 0 2.59e-07 0 2.59e-07 0 2.66e-07 0 2.66e-07 0 2.73e-07 0 2.73e-07 0 2.8e-07 0 2.8e-07 3.3 2.87e-07 3.3 2.871e-07 3.3 2.94e-07 3.3 2.941e-07 3.3 3.01e-07 3.3 3.011e-07 3.3 3.08e-07 3.3 3.081e-07 0 3.15e-07 0 3.151e-07 0 3.22e-07 0 3.221e-07 0 3.29e-07 0 3.29e-07 0 3.36e-07 0 3.36e-07 3.3 3.43e-07 3.3 3.43e-07 3.3 3.5e-07 3.3 3.5e-07 3.3 3.57e-07 3.3 3.57e-07 3.3 3.64e-07 3.3 3.64e-07 0 3.71e-07 0 3.71e-07 0 3.78e-07 0 3.78e-07 0 3.85e-07 0 3.85e-07 0 3.92e-07 0 3.921e-07 3.3 3.99e-07 3.3 3.991e-07 3.3 4.06e-07 3.3 4.061e-07 3.3 4.13e-07 3.3 4.131e-07 3.3 4.2e-07 3.3 4.201e-07 0 4.27e-07 0 4.271e-07 0 4.34e-07 0 4.34e-07 0 4.41e-07 0 4.41e-07 0 4.48e-07 0 4.48e-07 3.3 4.55e-07 3.3 4.55e-07 3.3 4.62e-07 3.3 4.62e-07 3.3 4.69e-07 3.3 4.69e-07 3.3 4.76e-07 3.3 4.76e-07 0 4.83e-07 0 4.83e-07 0 4.9e-07 0 4.9e-07 0 4.97e-07 0 4.97e-07 0 5.04e-07 0 5.04e-07 3.3 5.11e-07 3.3 5.11e-07 3.3 5.18e-07 3.3 5.18e-07 3.3 5.25e-07 3.3 5.25e-07 3.3 5.32e-07 3.3 5.32e-07 0 5.39e-07 0 5.39e-07 0 5.46e-07 0 5.46e-07 0 5.53e-07 0 5.53e-07 0 5.6e-07 0 5.6e-07 3.3 5.67e-07 3.3 5.671e-07 3.3 5.74e-07 3.3 5.741e-07 3.3 5.81e-07 3.3 5.811e-07 3.3 5.88e-07 3.3 5.881e-07 0 5.95e-07 0 5.951e-07 0 6.02e-07 0 6.021e-07 0 6.09e-07 0 6.091e-07 0 6.16e-07 0 6.161e-07 3.3 6.23e-07 3.3 6.231e-07 3.3 6.3e-07 3.3 6.301e-07 3.3 6.37e-07 3.3 6.371e-07 3.3 6.44e-07 3.3 6.441e-07 0 6.51e-07 0 6.51e-07 0 6.58e-07 0 6.58e-07 0 6.65e-07 0 6.65e-07 0 6.72e-07 0 6.72e-07 3.3 6.79e-07 3.3 6.79e-07 3.3 6.86e-07 3.3 6.86e-07 3.3 6.93e-07 3.3 6.93e-07 3.3 7e-07 3.3 7e-07 0 7.07e-07 0 7.07e-07 0 7.14e-07 0 7.14e-07 0 7.21e-07 0 7.21e-07 0 7.28e-07 0 7.28e-07 3.3 7.35e-07 3.3 7.35e-07 3.3 7.42e-07 3.3 7.42e-07 3.3 7.49e-07 3.3 7.49e-07 3.3 7.56e-07 3.3 7.56e-07 0 7.63e-07 0 7.63e-07 0 7.7e-07 0 7.7e-07 0 7.77e-07 0 7.77e-07 0 7.84e-07 0 7.841e-07 3.3 7.91e-07 3.3 7.911e-07 3.3 7.98e-07 3.3 7.981e-07 3.3 8.05e-07 3.3 8.051e-07 3.3 8.12e-07 3.3 8.121e-07 0 8.19e-07 0 8.191e-07 0 8.26e-07 0 8.261e-07 0 8.33e-07 0 8.331e-07 0 8.4e-07 0 8.401e-07 3.3 8.47e-07 3.3 8.471e-07 3.3 8.54e-07 3.3 8.541e-07 3.3 8.61e-07 3.3 8.61e-07 3.3 8.68e-07 3.3 8.68e-07 0 8.75e-07 0 8.75e-07 0 8.82e-07 0 8.82e-07 0 8.89e-07 0 8.89e-07 0 8.96e-07 0 8.96e-07 3.3 9.03e-07 3.3 9.03e-07 3.3 9.1e-07 3.3 9.1e-07 3.3 9.17e-07 3.3 9.17e-07 3.3 9.24e-07 3.3 9.24e-07 0 9.31e-07 0 9.31e-07 0 9.38e-07 0 9.38e-07 0 9.45e-07 0 9.45e-07 0 9.52e-07 0 9.52e-07 3.3 9.59e-07 3.3 9.59e-07 3.3 9.66e-07 3.3 9.66e-07 3.3 9.73e-07 3.3 9.73e-07 3.3 9.8e-07 3.3 9.8e-07 0 9.87e-07 0 9.87e-07 0 9.94e-07 0 9.94e-07 0 1.001e-06 0 1.001e-06 0 1.008e-06 0 1.008e-06 3.3 1.015e-06 3.3 1.015e-06 3.3 1.022e-06 3.3 1.022e-06 3.3 1.029e-06 3.3 1.029e-06 3.3 1.036e-06 3.3 1.036e-06 0 1.043e-06 0 1.043e-06 0 1.05e-06 0 1.05e-06 0 1.057e-06 0 1.057e-06 0 1.064e-06 0 1.064e-06 3.3 1.071e-06 3.3 1.071e-06 3.3 1.078e-06 3.3 1.078e-06 3.3 1.085e-06 3.3 1.085e-06 3.3 1.092e-06 3.3 1.092e-06 0 1.099e-06 0 1.099e-06 0 1.106e-06 0 1.106e-06 0 1.113e-06 0 1.113e-06 0 1.12e-06 0 1.12e-06 3.3 1.127e-06 3.3 1.127e-06 3.3 1.134e-06 3.3 1.134e-06 3.3 1.141e-06 3.3 1.141e-06 3.3 1.148e-06 3.3 1.148e-06 0 1.155e-06 0 1.155e-06 0 1.162e-06 0 1.162e-06 0 1.169e-06 0 1.169e-06 0 1.176e-06 0 1.176e-06 3.3 1.183e-06 3.3 1.183e-06 3.3 1.19e-06 3.3 1.19e-06 3.3 1.197e-06 3.3 1.197e-06 3.3 1.204e-06 3.3 1.204e-06 0 1.211e-06 0 1.211e-06 0 1.218e-06 0 1.218e-06 0 1.225e-06 0 1.225e-06 0 1.232e-06 0 1.232e-06 3.3 1.239e-06 3.3 1.239e-06 3.3 1.246e-06 3.3 1.246e-06 3.3 1.253e-06 3.3 1.253e-06 3.3 1.26e-06 3.3 1.26e-06 0 1.267e-06 0 1.267e-06 0 1.274e-06 0 1.274e-06 0 1.281e-06 0 1.281e-06 0 1.288e-06 0 1.288e-06 3.3 1.295e-06 3.3 1.295e-06 3.3 1.302e-06 3.3 1.302e-06 3.3 1.309e-06 3.3 1.309e-06 3.3 1.316e-06 3.3 1.316e-06 0 1.323e-06 0 1.323e-06 0 1.33e-06 0 1.33e-06 0 1.337e-06 0 1.337e-06 0 1.344e-06 0 1.344e-06 3.3 1.351e-06 3.3 1.351e-06 3.3 1.358e-06 3.3 1.358e-06 3.3 1.365e-06 3.3 1.365e-06 3.3 1.372e-06 3.3 1.372e-06 0 1.379e-06 0 1.379e-06 0 1.386e-06 0 1.386e-06 0 1.393e-06 0 1.393e-06 0 1.4e-06 0 1.4e-06 3.3 1.407e-06 3.3 1.407e-06 3.3 1.414e-06 3.3 1.414e-06 3.3 1.421e-06 3.3 1.421e-06 3.3 1.428e-06 3.3 1.428e-06 0 1.435e-06 0 1.435e-06 0 1.442e-06 0 1.442e-06 0 1.449e-06 0 1.449e-06 0 1.456e-06 0 1.456e-06 3.3 1.463e-06 3.3 1.463e-06 3.3 1.47e-06 3.3 1.47e-06 3.3 1.477e-06 3.3 1.477e-06 3.3 1.484e-06 3.3 1.484e-06 0 1.491e-06 0 1.491e-06 0 1.498e-06 0 1.498e-06 0 1.505e-06 0 1.505e-06 0 1.512e-06 0 1.512e-06 3.3 1.519e-06 3.3 1.519e-06 3.3 1.526e-06 3.3 1.526e-06 3.3 1.533e-06 3.3 1.533e-06 3.3 1.54e-06 3.3 1.54e-06 0 1.547e-06 0 1.547e-06 0 1.554e-06 0 1.554e-06 0 1.561e-06 0 1.561e-06 0 1.568e-06 0 1.568e-06 3.3 1.575e-06 3.3 1.575e-06 3.3 1.582e-06 3.3 1.582e-06 3.3 1.589e-06 3.3 1.589e-06 3.3 1.596e-06 3.3 1.596e-06 0 1.603e-06 0 1.603e-06 0 1.61e-06 0 1.61e-06 0 1.617e-06 0 1.617e-06 0 1.624e-06 0 1.624e-06 3.3 1.631e-06 3.3 1.631e-06 3.3 1.638e-06 3.3 1.638e-06 3.3 1.645e-06 3.3 1.645e-06 3.3 1.652e-06 3.3 1.652e-06 0 1.659e-06 0 1.659e-06 0 1.666e-06 0 1.666e-06 0 1.673e-06 0 1.673e-06 0 1.68e-06 0 1.68e-06 3.3 1.687e-06 3.3 1.687e-06 3.3 1.694e-06 3.3 1.694e-06 3.3 1.701e-06 3.3 1.701e-06 3.3 1.708e-06 3.3 1.708e-06 0 1.715e-06 0 1.715e-06 0 1.722e-06 0 1.722e-06 0 1.729e-06 0 1.729e-06 0 1.736e-06 0 1.736e-06 3.3 1.743e-06 3.3 1.743e-06 3.3 1.75e-06 3.3 1.75e-06 3.3 1.757e-06 3.3 1.757e-06 3.3 1.764e-06 3.3 1.764e-06 0 1.771e-06 0 1.771e-06 0 1.778e-06 0 1.778e-06 0 1.785e-06 0 1.785e-06 0 1.792e-06 0 1.792e-06 3.3 1.799e-06 3.3 1.799e-06 0 1.806e-06 0 1.806e-06 3.3 1.813e-06 3.3 1.813e-06 0)
CF0 F0 0 1e-14
CF1 F1 0 1e-14
CF2 F2 0 1e-14
CF3 F3 0 1e-14
CAEQB AEQB 0 1e-14
CP_N P_N 0 1e-14
CG_N G_N 0 1e-14
CCn4 Cn4 0 1e-14
.option method=gear
.control
tran 10p 1.82e-06
wrdata /home/ellis/EG-LOGIC/examples/alu74181/gf180mcuD/ALU181_sim.dat v(F0) v(F1) v(F2) v(F3) v(AEQB) v(P_N) v(G_N) v(Cn4)
quit
.endc
.end
