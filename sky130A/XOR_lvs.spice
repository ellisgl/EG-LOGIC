* NGSPICE file created from XOR.ext - technology: sky130A

.subckt XOR A B Y VDD VSS
X0 a_1028_164# B VDD VDD sky130_fd_pr__pfet_01v8 ad=0.2425 pd=1.485 as=0.14 ps=1.28 w=1 l=0.15
X1 Y a_744_n285# VSS VSS sky130_fd_pr__nfet_01v8 ad=0.3185 pd=2.28 as=0.15763 ps=1.135 w=0.65 l=0.15
X2 Y a_744_n285# a_1028_164# VDD sky130_fd_pr__pfet_01v8 ad=0.49 pd=2.98 as=0.2425 ps=1.485 w=1 l=0.15
X3 a_831_164# A a_744_n285# VDD sky130_fd_pr__pfet_01v8 ad=0.14 pd=1.28 as=0.285 ps=2.57 w=1 l=0.15
X4 VDD B a_831_164# VDD sky130_fd_pr__pfet_01v8 ad=0.285 pd=2.57 as=0.14 ps=1.28 w=1 l=0.15
X5 VSS A a_744_n285# VSS sky130_fd_pr__nfet_01v8 ad=0.091 pd=0.93 as=0.18525 ps=1.87 w=0.65 l=0.15
X6 VDD A a_1028_164# VDD sky130_fd_pr__pfet_01v8 ad=0.14 pd=1.28 as=0.285 ps=2.57 w=1 l=0.15
X7 a_744_n285# B VSS VSS sky130_fd_pr__nfet_01v8 ad=0.18525 pd=1.87 as=0.091 ps=0.93 w=0.65 l=0.15
X8 a_1115_n285# A Y VSS sky130_fd_pr__nfet_01v8 ad=0.091 pd=0.93 as=0.18525 ps=1.87 w=0.65 l=0.15
X9 VSS B a_1115_n285# VSS sky130_fd_pr__nfet_01v8 ad=0.15763 pd=1.135 as=0.091 ps=0.93 w=0.65 l=0.15
.ends
