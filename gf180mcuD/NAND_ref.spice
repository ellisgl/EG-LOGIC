* NAND reference (gf180mcuD)
.subckt NAND A B Y VDD VSS
X1 Y A VDD VDD pfet_03v3 w=2u l=0.28u
X2 VDD B Y VDD pfet_03v3 w=2u l=0.28u
X3 Y A n0_1 VSS nfet_03v3 w=1u l=0.28u
X4 n0_1 B VSS VSS nfet_03v3 w=1u l=0.28u
.ends
