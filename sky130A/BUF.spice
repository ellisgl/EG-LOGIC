* NGSPICE file created from BUF.ext - technology: sky130A

.subckt BUF A Y VDD VSS
X0 Y a_298_n201# VSS VSS sky130_fd_pr__nfet_01v8 ad=0.3185 pd=2.28 as=0.3185 ps=2.28 w=0.65 l=0.15
X1 a_298_n201# A VDD VDD sky130_fd_pr__pfet_01v8 ad=0.285 pd=2.57 as=0.285 ps=2.57 w=1 l=0.15
X2 Y a_298_n201# VDD VDD sky130_fd_pr__pfet_01v8 ad=0.49 pd=2.98 as=0.49 ps=2.98 w=1 l=0.15
X3 a_298_n201# A VSS VSS sky130_fd_pr__nfet_01v8 ad=0.18525 pd=1.87 as=0.18525 ps=1.87 w=0.65 l=0.15
C0 a_298_n201# VDD 0.29605f
C1 a_298_n201# A 0.05083f
C2 a_298_n201# Y 0.05741f
C3 VDD A 0.19786f
C4 VDD Y 0.37433f
C5 A Y 0
C6 Y VSS 0.61114f
C7 A VSS 0.53141f
C8 VDD VSS 3.74734f
C9 a_298_n201# VSS 0.25012f
.ends
