* ADD4 exhaustive test (gf180mcuD)
.include /home/ellis/pdk/gf180mcuD/libs.tech/ngspice/design.ngspice
.lib /home/ellis/pdk/gf180mcuD/libs.tech/ngspice/sm141064.ngspice typical

* NGSPICE file created from ADD4.ext - technology: gf180mcuD

.subckt AND A B Y VDD VSS a_323_n286# a_469_n286#
M0 VDD A a_323_n286# VDD pfet_03v3 ad=0.53p pd=2.53u as=0.9p ps=4.9u w=2u l=0.28u
M1 a_469_n286# A a_323_n286# VSS nfet_03v3 ad=0.265p pd=1.53u as=0.45p ps=2.9u w=1u l=0.28u
M2 Y a_323_n286# VSS VSS nfet_03v3 ad=0.625p pd=3.25u as=0.625p ps=3.25u w=1u l=0.28u
M3 VSS B a_469_n286# VSS nfet_03v3 ad=0.45p pd=2.9u as=0.265p ps=1.53u w=1u l=0.28u
M4 Y a_323_n286# VDD VDD pfet_03v3 ad=1.25p pd=5.25u as=1.25p ps=5.25u w=2u l=0.28u
M5 a_323_n286# B VDD VDD pfet_03v3 ad=0.9p pd=4.9u as=0.53p ps=2.53u w=2u l=0.28u
C0 a_323_n286# a_469_n286# 0.01435f
C1 a_323_n286# VDD 1.15177f
C2 a_323_n286# A 0.06277f
C3 a_323_n286# B 0.07031f
C4 a_323_n286# Y 0.12848f
C5 a_469_n286# VDD 0.00121f
C6 a_469_n286# Y 0
C7 VDD A 0.58621f
C8 VDD B 0.12259f
C9 VDD Y 0.55505f
C10 A B 0.05053f
C11 A Y 0
C12 B Y 0
C13 Y VSS 0.64505f
C14 B VSS 1.16274f
C15 A VSS 0.42529f
C16 VDD VSS 6.00341f
C17 a_469_n286# VSS 0.01616f
C18 a_323_n286# VSS 0.44193f
.ends

.subckt XOR A B Y VDD VSS a_1155_195# a_1609_n395# m1_n57_n1110# m2_n57_n1110# a_1009_n395#
+ a_1463_195#
M0 Y a_1009_n395# a_1463_195# VDD pfet_03v3 ad=1.25p pd=5.25u as=0.705p ps=2.705u w=2u l=0.28u
M1 a_1463_195# B VDD VDD pfet_03v3 ad=0.705p pd=2.705u as=0.53p ps=2.53u w=2u l=0.28u
M2 VDD A a_1463_195# VDD pfet_03v3 ad=0.53p pd=2.53u as=0.9p ps=4.9u w=2u l=0.28u
M3 a_1009_n395# B VSS VSS nfet_03v3 ad=0.45p pd=2.9u as=0.265p ps=1.53u w=1u l=0.28u
M4 a_1609_n395# A Y VSS nfet_03v3 ad=0.265p pd=1.53u as=0.45p ps=2.9u w=1u l=0.28u
M5 VDD B a_1155_195# VDD pfet_03v3 ad=0.9p pd=4.9u as=0.53p ps=2.53u w=2u l=0.28u
M6 VSS B a_1609_n395# VSS nfet_03v3 ad=0.3525p pd=1.705u as=0.265p ps=1.53u w=1u l=0.28u
M7 a_1155_195# A a_1009_n395# VDD pfet_03v3 ad=0.53p pd=2.53u as=0.9p ps=4.9u w=2u l=0.28u
M8 VSS A a_1009_n395# VSS nfet_03v3 ad=0.265p pd=1.53u as=0.45p ps=2.9u w=1u l=0.28u
M9 Y a_1009_n395# VSS VSS nfet_03v3 ad=0.625p pd=3.25u as=0.3525p ps=1.705u w=1u l=0.28u
C0 a_1009_n395# a_1155_195# 0.02315f
C1 a_1009_n395# a_1463_195# 0.49044f
C2 a_1009_n395# m1_n57_n1110# 0.01171f
C3 a_1009_n395# m2_n57_n1110# 0.00242f
C4 a_1009_n395# VDD 0.63712f
C5 a_1009_n395# A 0.09858f
C6 a_1009_n395# B 0.12558f
C7 a_1009_n395# Y 0.97225f
C8 a_1155_195# a_1463_195# 0
C9 a_1155_195# VDD 0.03214f
C10 a_1463_195# m2_n57_n1110# 0
C11 a_1463_195# VDD 0.83682f
C12 a_1463_195# A 0.04667f
C13 a_1463_195# B 0.04491f
C14 a_1463_195# Y 0.14545f
C15 a_1609_n395# VDD 0
C16 a_1609_n395# Y 0.01483f
C17 m1_n57_n1110# m2_n57_n1110# 0.55172f
C18 m1_n57_n1110# VDD 0.14282f
C19 m1_n57_n1110# A 0.07093f
C20 m1_n57_n1110# B 0.06992f
C21 m2_n57_n1110# VDD 0.13215f
C22 m2_n57_n1110# A 0.01915f
C23 m2_n57_n1110# B 0.01901f
C24 m2_n57_n1110# Y 0
C25 VDD A 1.14567f
C26 VDD B 0.31693f
C27 VDD Y 0.57323f
C28 A B 0.19007f
C29 A Y 0.03021f
C30 B Y 0.03299f
C31 Y VSS 1.00565f
C32 B VSS 2.34945f
C33 A VSS 1.14285f
C34 VDD VSS 8.40014f
C35 m2_n57_n1110# VSS 0.80082f
C36 m1_n57_n1110# VSS 1.26958f
C37 a_1609_n395# VSS 0.01427f
C38 a_1463_195# VSS 0.00312f
C39 a_1155_195# VSS 0.0013f
C40 a_1009_n395# VSS 0.69678f
.ends

.subckt OR A B Y VDD VSS a_651_86# a_505_n286#
M0 VDD B a_651_86# VDD pfet_03v3 ad=0.9p pd=4.9u as=0.53p ps=2.53u w=2u l=0.28u
M1 VSS A a_505_n286# VSS nfet_03v3 ad=0.265p pd=1.53u as=0.45p ps=2.9u w=1u l=0.28u
M2 a_651_86# A a_505_n286# VDD pfet_03v3 ad=0.53p pd=2.53u as=0.9p ps=4.9u w=2u l=0.28u
M3 a_505_n286# B VSS VSS nfet_03v3 ad=0.45p pd=2.9u as=0.265p ps=1.53u w=1u l=0.28u
M4 Y a_505_n286# VSS VSS nfet_03v3 ad=0.625p pd=3.25u as=0.625p ps=3.25u w=1u l=0.28u
M5 Y a_505_n286# VDD VDD pfet_03v3 ad=1.25p pd=5.25u as=1.25p ps=5.25u w=2u l=0.28u
C0 a_505_n286# a_651_86# 0.02609f
C1 a_505_n286# VDD 0.60195f
C2 a_505_n286# A 0.06265f
C3 a_505_n286# B 0.06594f
C4 a_505_n286# Y 0.12779f
C5 a_651_86# VDD 0.03536f
C6 a_651_86# Y 0
C7 VDD A 0.59831f
C8 VDD B 0.11999f
C9 VDD Y 0.63118f
C10 A B 0.05231f
C11 A Y 0
C12 B Y 0
C13 Y VSS 0.74439f
C14 B VSS 1.30453f
C15 A VSS 0.5295f
C16 VDD VSS 6.17565f
C17 a_651_86# VSS 0.00201f
C18 a_505_n286# VSS 0.79095f
.ends

.subckt ADD4 A0 A1 A2 A3 B0 B1 B2 B3 Cin S0 S1 S2 S3 Cout VDD VSS
XAND_3_3 XOR_3_2/A OR_2_4/Y OR_3_4/B VDD VSS AND_3_3/a_323_n286# AND_3_3/a_469_n286#
+ AND
XXOR_2_0 A2 B2 XOR_2_2/A VDD VSS XOR_2_0/a_1155_195# XOR_2_0/a_1609_n395# XOR_2_0/m1_n57_n1110#
+ XOR_2_0/m2_n57_n1110# XOR_2_0/a_1009_n395# XOR_2_0/a_1463_195# XOR
XAND_1_1 A1 B1 OR_1_4/A VDD VSS AND_1_1/a_323_n286# AND_1_1/a_469_n286# AND
XXOR_2_2 XOR_2_2/A OR_1_4/Y S2 VDD VSS XOR_2_2/a_1155_195# XOR_2_2/a_1609_n395# XOR_2_2/m1_n57_n1110#
+ XOR_2_2/m2_n57_n1110# XOR_2_2/a_1009_n395# XOR_2_2/a_1463_195# XOR
XAND_1_3 XOR_1_2/A OR_0_4/Y OR_1_4/B VDD VSS AND_1_3/a_323_n286# AND_1_3/a_469_n286#
+ AND
XXOR_0_0 A0 B0 XOR_0_2/A VDD VSS XOR_0_0/a_1155_195# XOR_0_0/a_1609_n395# XOR_0_0/m1_n57_n1110#
+ XOR_0_0/m2_n57_n1110# XOR_0_0/a_1009_n395# XOR_0_0/a_1463_195# XOR
XXOR_0_2 XOR_0_2/A Cin S0 VDD VSS XOR_0_2/a_1155_195# XOR_0_2/a_1609_n395# XOR_0_2/m1_n57_n1110#
+ XOR_0_2/m2_n57_n1110# XOR_0_2/a_1009_n395# XOR_0_2/a_1463_195# XOR
XOR_2_4 OR_2_4/A OR_2_4/B OR_2_4/Y VDD VSS OR_2_4/a_651_86# OR_2_4/a_505_n286# OR
XOR_0_4 OR_0_4/A OR_0_4/B OR_0_4/Y VDD VSS OR_0_4/a_651_86# OR_0_4/a_505_n286# OR
XAND_2_1 A2 B2 OR_2_4/A VDD VSS AND_2_1/a_323_n286# AND_2_1/a_469_n286# AND
XXOR_3_0 A3 B3 XOR_3_2/A VDD VSS XOR_3_0/a_1155_195# XOR_3_0/a_1609_n395# XOR_3_0/m1_n57_n1110#
+ XOR_3_0/m2_n57_n1110# XOR_3_0/a_1009_n395# XOR_3_0/a_1463_195# XOR
XXOR_3_2 XOR_3_2/A OR_2_4/Y S3 VDD VSS XOR_3_2/a_1155_195# XOR_3_2/a_1609_n395# XOR_3_2/m1_n57_n1110#
+ XOR_3_2/m2_n57_n1110# XOR_3_2/a_1009_n395# XOR_3_2/a_1463_195# XOR
XAND_2_3 XOR_2_2/A OR_1_4/Y OR_2_4/B VDD VSS AND_2_3/a_323_n286# AND_2_3/a_469_n286#
+ AND
XXOR_1_0 A1 B1 XOR_1_2/A VDD VSS XOR_1_0/a_1155_195# XOR_1_0/a_1609_n395# XOR_1_0/m1_n57_n1110#
+ XOR_1_0/m2_n57_n1110# XOR_1_0/a_1009_n395# XOR_1_0/a_1463_195# XOR
XAND_0_1 A0 B0 OR_0_4/A VDD VSS AND_0_1/a_323_n286# AND_0_1/a_469_n286# AND
XXOR_1_2 XOR_1_2/A OR_0_4/Y S1 VDD VSS XOR_1_2/a_1155_195# XOR_1_2/a_1609_n395# XOR_1_2/m1_n57_n1110#
+ XOR_1_2/m2_n57_n1110# XOR_1_2/a_1009_n395# XOR_1_2/a_1463_195# XOR
XAND_0_3 XOR_0_2/A Cin OR_0_4/B VDD VSS AND_0_3/a_323_n286# AND_0_3/a_469_n286# AND
XOR_3_4 OR_3_4/A OR_3_4/B Cout VDD VSS OR_3_4/a_651_86# OR_3_4/a_505_n286# OR
XOR_1_4 OR_1_4/A OR_1_4/B OR_1_4/Y VDD VSS OR_1_4/a_651_86# OR_1_4/a_505_n286# OR
XAND_3_1 A3 B3 OR_3_4/A VDD VSS AND_3_1/a_323_n286# AND_3_1/a_469_n286# AND
C0 AND_3_3/a_323_n286# OR_3_4/B 0
C1 AND_3_3/a_323_n286# VDD 0
C2 AND_3_3/a_323_n286# OR_2_4/Y 0.00607f
C3 AND_3_3/a_323_n286# S3 0.05109f
C4 AND_3_3/a_323_n286# OR_3_4/A 0.02161f
C5 AND_3_3/a_469_n286# OR_2_4/Y 0.00192f
C6 AND_3_3/a_469_n286# S3 0.0025f
C7 OR_3_4/B VDD 0.00881f
C8 OR_3_4/B OR_2_4/Y 0.07311f
C9 OR_3_4/B S3 0.38485f
C10 OR_3_4/B OR_3_4/a_505_n286# 0.00512f
C11 OR_3_4/B Cout 0
C12 OR_3_4/B OR_3_4/A 0.07914f
C13 XOR_2_0/a_1009_n395# A2 0.02464f
C14 XOR_2_0/a_1009_n395# B2 0.02203f
C15 XOR_2_0/a_1009_n395# XOR_2_2/A 0
C16 XOR_2_0/a_1009_n395# VDD 0
C17 XOR_2_0/a_1155_195# A2 0.00439f
C18 XOR_2_0/a_1155_195# B2 0.00211f
C19 XOR_2_0/a_1463_195# A2 0.01994f
C20 XOR_2_0/a_1463_195# B2 0.00694f
C21 XOR_2_0/a_1609_n395# A2 0.00117f
C22 XOR_2_0/a_1609_n395# B2 0.00209f
C23 XOR_2_0/m1_n57_n1110# A2 0.00831f
C24 XOR_2_0/m1_n57_n1110# B2 0.00831f
C25 XOR_2_0/m1_n57_n1110# VDD 0.00867f
C26 XOR_2_0/m1_n57_n1110# XOR_3_0/m1_n57_n1110# 0.00719f
C27 XOR_2_0/m1_n57_n1110# XOR_1_0/m1_n57_n1110# 0.00719f
C28 XOR_2_0/m2_n57_n1110# A2 0.1122f
C29 XOR_2_0/m2_n57_n1110# B2 0.1122f
C30 XOR_2_0/m2_n57_n1110# VDD 0.02427f
C31 XOR_2_0/m2_n57_n1110# XOR_3_0/m2_n57_n1110# 0.00788f
C32 XOR_2_0/m2_n57_n1110# XOR_1_0/m2_n57_n1110# 0.00788f
C33 A2 B2 0.28851f
C34 A2 XOR_2_2/A 0.17757f
C35 A2 VDD 1.02733f
C36 B2 XOR_2_2/A 0.09928f
C37 B2 VDD 0.06124f
C38 B2 OR_2_4/A 0
C39 XOR_2_2/A XOR_2_2/a_1009_n395# 0.0115f
C40 XOR_2_2/A XOR_2_2/a_1155_195# 0.00439f
C41 XOR_2_2/A XOR_2_2/a_1463_195# 0.01596f
C42 XOR_2_2/A XOR_2_2/m1_n57_n1110# 0.00842f
C43 XOR_2_2/A XOR_2_2/m2_n57_n1110# 0.10596f
C44 XOR_2_2/A S2 0.02094f
C45 XOR_2_2/A VDD 1.76227f
C46 XOR_2_2/A AND_2_1/a_323_n286# 0.03607f
C47 XOR_2_2/A AND_2_1/a_469_n286# 0.00132f
C48 XOR_2_2/A OR_2_4/A 0.82843f
C49 XOR_2_2/A OR_1_4/Y 0.02835f
C50 AND_1_1/a_323_n286# OR_1_4/A 0.00117f
C51 AND_1_1/a_323_n286# VDD 0
C52 AND_1_1/a_323_n286# XOR_1_2/A 0.03607f
C53 AND_1_1/a_469_n286# XOR_1_2/A 0.00132f
C54 OR_1_4/A AND_1_3/a_323_n286# 0.02161f
C55 OR_1_4/A OR_1_4/B 0.02713f
C56 OR_1_4/A VDD 1.1262f
C57 OR_1_4/A OR_0_4/Y 0.36884f
C58 OR_1_4/A B1 0
C59 OR_1_4/A XOR_1_2/A 0.82843f
C60 OR_1_4/A XOR_1_2/a_1009_n395# 0.04696f
C61 OR_1_4/A XOR_1_2/a_1155_195# 0.00441f
C62 OR_1_4/A XOR_1_2/a_1463_195# 0.03298f
C63 OR_1_4/A XOR_1_2/a_1609_n395# 0.00192f
C64 OR_1_4/A XOR_1_2/m1_n57_n1110# 0.01038f
C65 OR_1_4/A XOR_1_2/m2_n57_n1110# 0.10195f
C66 OR_1_4/A S1 0.61797f
C67 OR_1_4/A OR_1_4/Y 0.09092f
C68 XOR_2_2/a_1009_n395# S2 0
C69 XOR_2_2/a_1009_n395# VDD 0
C70 XOR_2_2/a_1009_n395# OR_2_4/A 0.04696f
C71 XOR_2_2/a_1009_n395# OR_1_4/Y 0.0186f
C72 XOR_2_2/a_1155_195# OR_2_4/A 0.00441f
C73 XOR_2_2/a_1463_195# OR_2_4/A 0.03298f
C74 XOR_2_2/a_1463_195# OR_1_4/Y 0.00147f
C75 XOR_2_2/a_1609_n395# OR_2_4/A 0.00192f
C76 XOR_2_2/a_1609_n395# OR_1_4/Y 0.00209f
C77 XOR_2_2/m1_n57_n1110# VDD 0.00839f
C78 XOR_2_2/m1_n57_n1110# OR_2_4/A 0.01038f
C79 XOR_2_2/m1_n57_n1110# XOR_3_2/m1_n57_n1110# 0.00719f
C80 XOR_2_2/m1_n57_n1110# XOR_1_2/m1_n57_n1110# 0.00719f
C81 XOR_2_2/m1_n57_n1110# OR_1_4/Y 0.00754f
C82 XOR_2_2/m2_n57_n1110# VDD 0.02337f
C83 XOR_2_2/m2_n57_n1110# OR_2_4/A 0.10195f
C84 XOR_2_2/m2_n57_n1110# XOR_3_2/m2_n57_n1110# 0.00788f
C85 XOR_2_2/m2_n57_n1110# XOR_1_2/m2_n57_n1110# 0.00788f
C86 XOR_2_2/m2_n57_n1110# OR_1_4/Y 0.10992f
C87 S2 VDD 0.18624f
C88 S2 OR_2_4/a_505_n286# 0.01942f
C89 S2 OR_2_4/Y 1.21468f
C90 S2 OR_2_4/A 0.61797f
C91 S2 AND_2_3/a_323_n286# 0.05109f
C92 S2 AND_2_3/a_469_n286# 0.0025f
C93 S2 OR_2_4/B 0.31946f
C94 S2 OR_1_4/Y 0.38995f
C95 AND_1_3/a_323_n286# OR_1_4/B 0
C96 AND_1_3/a_323_n286# VDD 0
C97 AND_1_3/a_323_n286# OR_0_4/Y 0.00607f
C98 AND_1_3/a_323_n286# S1 0.05109f
C99 AND_1_3/a_469_n286# OR_0_4/Y 0.00192f
C100 AND_1_3/a_469_n286# S1 0.0025f
C101 OR_1_4/B VDD 0.00719f
C102 OR_1_4/B OR_0_4/Y 0.19354f
C103 OR_1_4/B S1 0.31946f
C104 OR_1_4/B OR_1_4/a_505_n286# 0
C105 OR_1_4/B OR_1_4/Y 0.04549f
C106 XOR_0_0/a_1009_n395# VDD 0
C107 XOR_0_0/a_1009_n395# A0 0.02113f
C108 XOR_0_0/a_1009_n395# B0 0.00838f
C109 XOR_0_0/a_1009_n395# XOR_0_2/A 0
C110 XOR_0_0/a_1009_n395# Cin 0.04826f
C111 XOR_0_0/a_1155_195# A0 0.00439f
C112 XOR_0_0/a_1155_195# Cin 0.00351f
C113 XOR_0_0/a_1463_195# A0 0.01994f
C114 XOR_0_0/a_1463_195# Cin 0.01562f
C115 XOR_0_0/a_1609_n395# B0 0.00209f
C116 XOR_0_0/a_1609_n395# Cin 0.00231f
C117 XOR_0_0/m1_n57_n1110# VDD 0.00673f
C118 XOR_0_0/m1_n57_n1110# A0 0.00831f
C119 XOR_0_0/m1_n57_n1110# B0 0.00831f
C120 XOR_0_0/m1_n57_n1110# Cin 0.00829f
C121 XOR_0_0/m1_n57_n1110# XOR_1_0/m1_n57_n1110# 0.00719f
C122 XOR_0_0/m2_n57_n1110# VDD 0.02267f
C123 XOR_0_0/m2_n57_n1110# A0 0.10999f
C124 XOR_0_0/m2_n57_n1110# B0 0.10603f
C125 XOR_0_0/m2_n57_n1110# Cin 0.09925f
C126 XOR_0_0/m2_n57_n1110# XOR_1_0/m2_n57_n1110# 0.00788f
C127 VDD A0 1.02733f
C128 VDD B0 0.01159f
C129 VDD XOR_0_2/A 1.76227f
C130 VDD XOR_0_2/a_1009_n395# 0
C131 VDD XOR_0_2/m1_n57_n1110# 0.00644f
C132 VDD XOR_0_2/m2_n57_n1110# 0.02176f
C133 VDD Cin 0.15565f
C134 VDD S0 0.18624f
C135 VDD OR_2_4/a_505_n286# 0.00337f
C136 VDD OR_2_4/a_651_86# 0.00205f
C137 VDD OR_2_4/Y 0.55966f
C138 VDD OR_0_4/a_505_n286# 0.00337f
C139 VDD OR_0_4/a_651_86# 0.00205f
C140 VDD OR_0_4/Y 0.55966f
C141 VDD AND_2_1/a_323_n286# 0
C142 VDD OR_2_4/A 1.12625f
C143 VDD XOR_3_0/a_1009_n395# 0
C144 VDD XOR_3_0/m1_n57_n1110# 0.00867f
C145 VDD XOR_3_0/m2_n57_n1110# 0.02427f
C146 VDD A3 1.0273f
C147 VDD B3 0.06124f
C148 VDD XOR_3_2/A 1.76221f
C149 VDD XOR_3_2/a_1009_n395# 0
C150 VDD XOR_3_2/m1_n57_n1110# 0.00838f
C151 VDD XOR_3_2/m2_n57_n1110# 0.02336f
C152 VDD S3 0.38736f
C153 VDD AND_2_3/a_323_n286# 0
C154 VDD OR_2_4/B 0.00719f
C155 VDD XOR_1_0/a_1009_n395# 0
C156 VDD XOR_1_0/m1_n57_n1110# 0.00866f
C157 VDD XOR_1_0/m2_n57_n1110# 0.02427f
C158 VDD A1 1.0273f
C159 VDD B1 0.06124f
C160 VDD XOR_1_2/A 1.7622f
C161 VDD AND_0_1/a_323_n286# 0
C162 VDD OR_0_4/A 1.12625f
C163 VDD XOR_1_2/a_1009_n395# 0
C164 VDD XOR_1_2/m1_n57_n1110# 0.00837f
C165 VDD XOR_1_2/m2_n57_n1110# 0.02336f
C166 VDD S1 0.18623f
C167 VDD AND_0_3/a_323_n286# 0
C168 VDD OR_0_4/B 0.0045f
C169 VDD OR_3_4/a_505_n286# 0.00515f
C170 VDD OR_3_4/a_651_86# 0.00205f
C171 VDD Cout 0.06993f
C172 VDD OR_1_4/a_505_n286# 0.00337f
C173 VDD OR_1_4/a_651_86# 0.00205f
C174 VDD OR_1_4/Y 0.55965f
C175 VDD AND_3_1/a_323_n286# 0
C176 VDD OR_3_4/A 1.12638f
C177 A0 B0 0.02551f
C178 A0 XOR_0_2/A 0.17385f
C179 A0 Cin 0.42303f
C180 B0 XOR_0_2/A 0.02022f
C181 B0 Cin 0.83064f
C182 B0 OR_0_4/A 0
C183 XOR_0_2/A XOR_0_2/a_1009_n395# 0.0115f
C184 XOR_0_2/A XOR_0_2/a_1155_195# 0.00439f
C185 XOR_0_2/A XOR_0_2/a_1463_195# 0.01596f
C186 XOR_0_2/A XOR_0_2/m1_n57_n1110# 0.00842f
C187 XOR_0_2/A XOR_0_2/m2_n57_n1110# 0.10596f
C188 XOR_0_2/A Cin 0.52968f
C189 XOR_0_2/A S0 0.02094f
C190 XOR_0_2/A AND_0_1/a_323_n286# 0.03607f
C191 XOR_0_2/A AND_0_1/a_469_n286# 0.00132f
C192 XOR_0_2/A OR_0_4/A 0.82843f
C193 XOR_0_2/a_1009_n395# Cin 0.0186f
C194 XOR_0_2/a_1009_n395# S0 0
C195 XOR_0_2/a_1009_n395# OR_0_4/A 0.04696f
C196 XOR_0_2/a_1155_195# OR_0_4/A 0.00441f
C197 XOR_0_2/a_1463_195# Cin 0.00147f
C198 XOR_0_2/a_1463_195# OR_0_4/A 0.03298f
C199 XOR_0_2/a_1609_n395# Cin 0.00209f
C200 XOR_0_2/a_1609_n395# OR_0_4/A 0.00192f
C201 XOR_0_2/m1_n57_n1110# Cin 0.00842f
C202 XOR_0_2/m1_n57_n1110# OR_0_4/A 0.01038f
C203 XOR_0_2/m1_n57_n1110# XOR_1_2/m1_n57_n1110# 0.00719f
C204 XOR_0_2/m2_n57_n1110# Cin 0.10992f
C205 XOR_0_2/m2_n57_n1110# OR_0_4/A 0.10195f
C206 XOR_0_2/m2_n57_n1110# XOR_1_2/m2_n57_n1110# 0.00788f
C207 Cin S0 0.09832f
C208 Cin AND_0_1/a_323_n286# 0.01822f
C209 Cin AND_0_1/a_469_n286# 0.00322f
C210 Cin OR_0_4/A 0.42824f
C211 S0 OR_0_4/a_505_n286# 0.01942f
C212 S0 OR_0_4/Y 1.21468f
C213 S0 OR_0_4/A 0.61797f
C214 S0 AND_0_3/a_323_n286# 0.05109f
C215 S0 AND_0_3/a_469_n286# 0.0025f
C216 S0 OR_0_4/B 0.28915f
C217 OR_2_4/a_505_n286# OR_2_4/Y 0.04124f
C218 OR_2_4/a_505_n286# OR_2_4/B 0
C219 OR_2_4/a_651_86# OR_2_4/Y 0.00574f
C220 OR_2_4/Y OR_2_4/A 0.09092f
C221 OR_2_4/Y XOR_3_2/A 0.02835f
C222 OR_2_4/Y XOR_3_2/a_1009_n395# 0.0186f
C223 OR_2_4/Y XOR_3_2/a_1463_195# 0.00147f
C224 OR_2_4/Y XOR_3_2/a_1609_n395# 0.00209f
C225 OR_2_4/Y XOR_3_2/m1_n57_n1110# 0.00754f
C226 OR_2_4/Y XOR_3_2/m2_n57_n1110# 0.10991f
C227 OR_2_4/Y S3 0.44324f
C228 OR_2_4/Y OR_2_4/B 0.04549f
C229 OR_2_4/Y OR_1_4/Y 0.00857f
C230 OR_2_4/Y OR_3_4/A 0.36892f
C231 OR_0_4/a_505_n286# OR_0_4/Y 0.04124f
C232 OR_0_4/a_505_n286# OR_0_4/B 0
C233 OR_0_4/a_651_86# OR_0_4/Y 0.00574f
C234 OR_0_4/Y XOR_1_2/A 0.02835f
C235 OR_0_4/Y OR_0_4/A 0.09092f
C236 OR_0_4/Y XOR_1_2/a_1009_n395# 0.0186f
C237 OR_0_4/Y XOR_1_2/a_1463_195# 0.00147f
C238 OR_0_4/Y XOR_1_2/a_1609_n395# 0.00209f
C239 OR_0_4/Y XOR_1_2/m1_n57_n1110# 0.00754f
C240 OR_0_4/Y XOR_1_2/m2_n57_n1110# 0.10991f
C241 OR_0_4/Y S1 0.38995f
C242 OR_0_4/Y OR_0_4/B 0.04526f
C243 OR_0_4/Y OR_1_4/Y 0.00857f
C244 AND_2_1/a_323_n286# OR_2_4/A 0.00117f
C245 OR_2_4/A AND_2_3/a_323_n286# 0.02161f
C246 OR_2_4/A OR_2_4/B 0.02713f
C247 OR_2_4/A OR_1_4/Y 0.36884f
C248 XOR_3_0/a_1009_n395# A3 0.02464f
C249 XOR_3_0/a_1009_n395# B3 0.02203f
C250 XOR_3_0/a_1009_n395# XOR_3_2/A 0
C251 XOR_3_0/a_1155_195# A3 0.00439f
C252 XOR_3_0/a_1155_195# B3 0.00211f
C253 XOR_3_0/a_1463_195# A3 0.01994f
C254 XOR_3_0/a_1463_195# B3 0.00694f
C255 XOR_3_0/a_1609_n395# A3 0.00117f
C256 XOR_3_0/a_1609_n395# B3 0.00209f
C257 XOR_3_0/m1_n57_n1110# A3 0.00831f
C258 XOR_3_0/m1_n57_n1110# B3 0.00831f
C259 XOR_3_0/m2_n57_n1110# A3 0.11219f
C260 XOR_3_0/m2_n57_n1110# B3 0.11218f
C261 A3 B3 0.28851f
C262 A3 XOR_3_2/A 0.17757f
C263 B3 XOR_3_2/A 0.09928f
C264 B3 OR_3_4/A 0
C265 XOR_3_2/A XOR_3_2/a_1009_n395# 0.0115f
C266 XOR_3_2/A XOR_3_2/a_1155_195# 0.00439f
C267 XOR_3_2/A XOR_3_2/a_1463_195# 0.01596f
C268 XOR_3_2/A XOR_3_2/m1_n57_n1110# 0.00842f
C269 XOR_3_2/A XOR_3_2/m2_n57_n1110# 0.10596f
C270 XOR_3_2/A S3 0.02094f
C271 XOR_3_2/A AND_3_1/a_323_n286# 0.03607f
C272 XOR_3_2/A AND_3_1/a_469_n286# 0.00132f
C273 XOR_3_2/A OR_3_4/A 0.82843f
C274 XOR_3_2/a_1009_n395# S3 0
C275 XOR_3_2/a_1009_n395# OR_3_4/A 0.04696f
C276 XOR_3_2/a_1155_195# OR_3_4/A 0.00441f
C277 XOR_3_2/a_1463_195# OR_3_4/A 0.03298f
C278 XOR_3_2/a_1609_n395# OR_3_4/A 0.00192f
C279 XOR_3_2/m1_n57_n1110# OR_3_4/A 0.01037f
C280 XOR_3_2/m2_n57_n1110# OR_3_4/A 0.10194f
C281 S3 OR_3_4/a_505_n286# 0.03662f
C282 S3 OR_3_4/a_651_86# 0.00386f
C283 S3 Cout 0.41883f
C284 S3 OR_3_4/A 0.60426f
C285 AND_2_3/a_323_n286# OR_2_4/B 0
C286 AND_2_3/a_323_n286# OR_1_4/Y 0.00607f
C287 AND_2_3/a_469_n286# OR_1_4/Y 0.00192f
C288 OR_2_4/B OR_1_4/Y 0.19354f
C289 XOR_1_0/a_1009_n395# A1 0.02464f
C290 XOR_1_0/a_1009_n395# B1 0.02203f
C291 XOR_1_0/a_1009_n395# XOR_1_2/A 0
C292 XOR_1_0/a_1155_195# A1 0.00439f
C293 XOR_1_0/a_1155_195# B1 0.00211f
C294 XOR_1_0/a_1463_195# A1 0.01994f
C295 XOR_1_0/a_1463_195# B1 0.00694f
C296 XOR_1_0/a_1609_n395# A1 0.00117f
C297 XOR_1_0/a_1609_n395# B1 0.00209f
C298 XOR_1_0/m1_n57_n1110# A1 0.00831f
C299 XOR_1_0/m1_n57_n1110# B1 0.00831f
C300 XOR_1_0/m2_n57_n1110# A1 0.11217f
C301 XOR_1_0/m2_n57_n1110# B1 0.11218f
C302 A1 B1 0.28851f
C303 A1 XOR_1_2/A 0.17757f
C304 B1 XOR_1_2/A 0.09928f
C305 XOR_1_2/A XOR_1_2/a_1009_n395# 0.0115f
C306 XOR_1_2/A XOR_1_2/a_1155_195# 0.00439f
C307 XOR_1_2/A XOR_1_2/a_1463_195# 0.01596f
C308 XOR_1_2/A XOR_1_2/m1_n57_n1110# 0.00841f
C309 XOR_1_2/A XOR_1_2/m2_n57_n1110# 0.10593f
C310 XOR_1_2/A S1 0.02094f
C311 AND_0_1/a_323_n286# OR_0_4/A 0.00117f
C312 OR_0_4/A AND_0_3/a_323_n286# 0.02161f
C313 OR_0_4/A OR_0_4/B 0.027f
C314 XOR_1_2/a_1009_n395# S1 0
C315 S1 OR_1_4/a_505_n286# 0.01942f
C316 S1 OR_1_4/Y 1.21468f
C317 AND_0_3/a_323_n286# OR_0_4/B 0
C318 OR_3_4/a_505_n286# Cout 0
C319 OR_1_4/a_505_n286# OR_1_4/Y 0.04124f
C320 OR_1_4/a_651_86# OR_1_4/Y 0.00574f
C321 AND_3_1/a_323_n286# OR_3_4/A 0.00117f
C322 OR_3_4/A VSS 0.63461f
C323 AND_3_1/a_469_n286# VSS 0
C324 AND_3_1/a_323_n286# VSS 0.00443f
C325 OR_1_4/Y VSS 2.80606f
C326 OR_1_4/a_505_n286# VSS 0.00129f
C327 Cout VSS 0.43839f
C328 OR_3_4/a_505_n286# VSS 0.00123f
C329 OR_0_4/B VSS 0.5009f
C330 AND_0_3/a_469_n286# VSS 0
C331 AND_0_3/a_323_n286# VSS 0.00181f
C332 S1 VSS 0.75693f
C333 XOR_1_2/m2_n57_n1110# VSS 0.02335f
C334 XOR_1_2/m1_n57_n1110# VSS 0.00837f
C335 XOR_1_2/a_1009_n395# VSS 0
C336 OR_0_4/A VSS 0.59787f
C337 AND_0_1/a_323_n286# VSS 0
C338 XOR_1_2/A VSS 1.22696f
C339 B1 VSS 1.65852f
C340 A1 VSS 0.66993f
C341 XOR_1_0/m2_n57_n1110# VSS 0.02335f
C342 XOR_1_0/m1_n57_n1110# VSS 0.00837f
C343 XOR_1_0/a_1009_n395# VSS 0
C344 OR_2_4/B VSS 0.42834f
C345 AND_2_3/a_323_n286# VSS 0
C346 S3 VSS 0.76172f
C347 XOR_3_2/m2_n57_n1110# VSS 0.02174f
C348 XOR_3_2/m1_n57_n1110# VSS 0.00642f
C349 XOR_3_2/a_1009_n395# VSS 0
C350 XOR_3_2/A VSS 1.22077f
C351 B3 VSS 1.65839f
C352 A3 VSS 0.66348f
C353 XOR_3_0/m2_n57_n1110# VSS 0.02174f
C354 XOR_3_0/m1_n57_n1110# VSS 0.00642f
C355 XOR_3_0/a_1009_n395# VSS 0
C356 OR_2_4/A VSS 0.63978f
C357 AND_2_1/a_469_n286# VSS 0
C358 AND_2_1/a_323_n286# VSS 0.00448f
C359 OR_0_4/Y VSS 2.8062f
C360 OR_0_4/a_505_n286# VSS 0.00129f
C361 OR_2_4/Y VSS 2.80603f
C362 OR_2_4/a_505_n286# VSS 0.00129f
C363 S0 VSS 0.95239f
C364 Cin VSS 3.17074f
C365 XOR_0_2/m2_n57_n1110# VSS 0.02337f
C366 XOR_0_2/m1_n57_n1110# VSS 0.00839f
C367 XOR_0_2/a_1009_n395# VSS 0
C368 XOR_0_2/A VSS 1.00917f
C369 B0 VSS 1.51176f
C370 A0 VSS 0.57461f
C371 VDD VSS 32.70972f
C372 XOR_0_0/m2_n57_n1110# VSS 0.02337f
C373 XOR_0_0/m1_n57_n1110# VSS 0.00839f
C374 XOR_0_0/a_1009_n395# VSS 0
C375 OR_1_4/B VSS 0.42834f
C376 AND_1_3/a_323_n286# VSS 0
C377 S2 VSS 0.75687f
C378 XOR_2_2/m2_n57_n1110# VSS 0.02337f
C379 XOR_2_2/m1_n57_n1110# VSS 0.00839f
C380 XOR_2_2/a_1009_n395# VSS 0
C381 OR_1_4/A VSS 0.63979f
C382 AND_1_1/a_469_n286# VSS 0
C383 AND_1_1/a_323_n286# VSS 0.00448f
C384 XOR_2_2/A VSS 1.22697f
C385 B2 VSS 1.65859f
C386 A2 VSS 0.66993f
C387 XOR_2_0/m2_n57_n1110# VSS 0.02337f
C388 XOR_2_0/m1_n57_n1110# VSS 0.00839f
C389 XOR_2_0/a_1009_n395# VSS 0
C390 OR_3_4/B VSS 0.4282f
C391 AND_3_3/a_323_n286# VSS 0
.ends

XDUT A0 A1 A2 A3 B0 B1 B2 B3 Cin S0 S1 S2 S3 Cout VDD VSS ADD4
VDD VDD 0 3.3
VSS VSS 0 0
VA0 A0 0 PWL(0 0 3e-09 0 3.05e-09 3.3 6e-09 3.3 6.05e-09 3.3 9e-09 3.3 9.05e-09 0 1.2e-08 0 1.205e-08 0 1.5e-08 0 1.505e-08 3.3 1.8e-08 3.3 1.805e-08 3.3 2.1e-08 3.3 2.105e-08 0 2.4e-08 0 2.405e-08 0 2.7e-08 0 2.705e-08 3.3 3e-08 3.3 3.005e-08 3.3 3.3e-08 3.3 3.305e-08 0 3.6e-08 0 3.605e-08 0 3.9e-08 0 3.905e-08 3.3 4.2e-08 3.3 4.205e-08 3.3 4.5e-08 3.3 4.505e-08 0 4.8e-08 0 4.805e-08 0 5.1e-08 0 5.105e-08 3.3 5.4e-08 3.3 5.405e-08 3.3 5.7e-08 3.3 5.705e-08 0 6e-08 0 6.005e-08 0 6.3e-08 0 6.305e-08 3.3 6.6e-08 3.3 6.605e-08 3.3 6.9e-08 3.3 6.905e-08 0 7.2e-08 0 7.205e-08 0 7.5e-08 0 7.505e-08 3.3 7.8e-08 3.3 7.805e-08 3.3 8.1e-08 3.3 8.105e-08 0 8.4e-08 0 8.405e-08 0 8.7e-08 0 8.705e-08 3.3 9e-08 3.3 9.005e-08 3.3 9.3e-08 3.3 9.305e-08 0 9.6e-08 0 9.605e-08 0 9.9e-08 0 9.905e-08 3.3 1.02e-07 3.3 1.021e-07 3.3 1.05e-07 3.3 1.051e-07 0 1.08e-07 0 1.081e-07 0 1.11e-07 0 1.111e-07 3.3 1.14e-07 3.3 1.141e-07 3.3 1.17e-07 3.3 1.171e-07 0 1.2e-07 0 1.2e-07 0 1.23e-07 0 1.231e-07 3.3 1.26e-07 3.3 1.26e-07 3.3 1.29e-07 3.3 1.291e-07 0 1.32e-07 0 1.32e-07 0 1.35e-07 0 1.351e-07 3.3 1.38e-07 3.3 1.38e-07 3.3 1.41e-07 3.3 1.411e-07 0 1.44e-07 0 1.44e-07 0 1.47e-07 0 1.471e-07 3.3 1.5e-07 3.3 1.5e-07 3.3 1.53e-07 3.3 1.531e-07 0 1.56e-07 0 1.56e-07 0 1.59e-07 0 1.591e-07 3.3 1.62e-07 3.3 1.62e-07 3.3 1.65e-07 3.3 1.651e-07 0 1.68e-07 0 1.68e-07 0 1.71e-07 0 1.711e-07 3.3 1.74e-07 3.3 1.741e-07 3.3 1.77e-07 3.3 1.771e-07 0 1.8e-07 0 1.801e-07 0 1.83e-07 0 1.831e-07 3.3 1.86e-07 3.3 1.861e-07 3.3 1.89e-07 3.3 1.891e-07 0 1.92e-07 0 1.921e-07 0 1.95e-07 0 1.95e-07 3.3 1.98e-07 3.3 1.981e-07 3.3 2.01e-07 3.3 2.01e-07 0 2.04e-07 0 2.041e-07 0 2.07e-07 0 2.07e-07 3.3 2.1e-07 3.3 2.101e-07 3.3 2.13e-07 3.3 2.13e-07 0 2.16e-07 0 2.161e-07 0 2.19e-07 0 2.19e-07 3.3 2.22e-07 3.3 2.221e-07 3.3 2.25e-07 3.3 2.25e-07 0 2.28e-07 0 2.281e-07 0 2.31e-07 0 2.31e-07 3.3 2.34e-07 3.3 2.341e-07 3.3 2.37e-07 3.3 2.37e-07 0 2.4e-07 0 2.4e-07 0 2.43e-07 0 2.43e-07 3.3 2.46e-07 3.3 2.461e-07 3.3 2.49e-07 3.3 2.491e-07 0 2.52e-07 0 2.52e-07 0 2.55e-07 0 2.55e-07 3.3 2.58e-07 3.3 2.581e-07 3.3 2.61e-07 3.3 2.611e-07 0 2.64e-07 0 2.64e-07 0 2.67e-07 0 2.67e-07 3.3 2.7e-07 3.3 2.701e-07 3.3 2.73e-07 3.3 2.731e-07 0 2.76e-07 0 2.76e-07 0 2.79e-07 0 2.791e-07 3.3 2.82e-07 3.3 2.821e-07 3.3 2.85e-07 3.3 2.851e-07 0 2.88e-07 0 2.88e-07 0 2.91e-07 0 2.911e-07 3.3 2.94e-07 3.3 2.941e-07 3.3 2.97e-07 3.3 2.97e-07 0 3e-07 0 3e-07 0 3.03e-07 0 3.031e-07 3.3 3.06e-07 3.3 3.061e-07 3.3 3.09e-07 3.3 3.09e-07 0 3.12e-07 0 3.12e-07 0 3.15e-07 0 3.151e-07 3.3 3.18e-07 3.3 3.181e-07 3.3 3.21e-07 3.3 3.21e-07 0 3.24e-07 0 3.24e-07 0 3.27e-07 0 3.271e-07 3.3 3.3e-07 3.3 3.301e-07 3.3 3.33e-07 3.3 3.33e-07 0 3.36e-07 0 3.36e-07 0 3.39e-07 0 3.391e-07 3.3 3.42e-07 3.3 3.421e-07 3.3 3.45e-07 3.3 3.45e-07 0 3.48e-07 0 3.48e-07 0 3.51e-07 0 3.511e-07 3.3 3.54e-07 3.3 3.541e-07 3.3 3.57e-07 3.3 3.57e-07 0 3.6e-07 0 3.6e-07 0 3.63e-07 0 3.631e-07 3.3 3.66e-07 3.3 3.661e-07 3.3 3.69e-07 3.3 3.69e-07 0 3.72e-07 0 3.72e-07 0 3.75e-07 0 3.751e-07 3.3 3.78e-07 3.3 3.781e-07 3.3 3.81e-07 3.3 3.81e-07 0 3.84e-07 0 3.841e-07 0 3.87e-07 0 3.871e-07 3.3 3.9e-07 3.3 3.9e-07 3.3 3.93e-07 3.3 3.93e-07 0 3.96e-07 0 3.961e-07 0 3.99e-07 0 3.991e-07 3.3 4.02e-07 3.3 4.02e-07 3.3 4.05e-07 3.3 4.05e-07 0 4.08e-07 0 4.081e-07 0 4.11e-07 0 4.111e-07 3.3 4.14e-07 3.3 4.14e-07 3.3 4.17e-07 3.3 4.17e-07 0 4.2e-07 0 4.201e-07 0 4.23e-07 0 4.231e-07 3.3 4.26e-07 3.3 4.26e-07 3.3 4.29e-07 3.3 4.29e-07 0 4.32e-07 0 4.321e-07 0 4.35e-07 0 4.351e-07 3.3 4.38e-07 3.3 4.38e-07 3.3 4.41e-07 3.3 4.41e-07 0 4.44e-07 0 4.441e-07 0 4.47e-07 0 4.471e-07 3.3 4.5e-07 3.3 4.5e-07 3.3 4.53e-07 3.3 4.53e-07 0 4.56e-07 0 4.561e-07 0 4.59e-07 0 4.591e-07 3.3 4.62e-07 3.3 4.62e-07 3.3 4.65e-07 3.3 4.65e-07 0 4.68e-07 0 4.681e-07 0 4.71e-07 0 4.711e-07 3.3 4.74e-07 3.3 4.74e-07 3.3 4.77e-07 3.3 4.771e-07 0 4.8e-07 0 4.8e-07 0 4.83e-07 0 4.83e-07 3.3 4.86e-07 3.3 4.86e-07 3.3 4.89e-07 3.3 4.891e-07 0 4.92e-07 0 4.921e-07 0 4.95e-07 0 4.951e-07 3.3 4.98e-07 3.3 4.981e-07 3.3 5.01e-07 3.3 5.01e-07 0 5.04e-07 0 5.04e-07 0 5.07e-07 0 5.07e-07 3.3 5.1e-07 3.3 5.1e-07 3.3 5.13e-07 3.3 5.131e-07 0 5.16e-07 0 5.161e-07 0 5.19e-07 0 5.191e-07 3.3 5.22e-07 3.3 5.221e-07 3.3 5.25e-07 3.3 5.25e-07 0 5.28e-07 0 5.28e-07 0 5.31e-07 0 5.31e-07 3.3 5.34e-07 3.3 5.34e-07 3.3 5.37e-07 3.3 5.371e-07 0 5.4e-07 0 5.401e-07 0 5.43e-07 0 5.431e-07 3.3 5.46e-07 3.3 5.461e-07 3.3 5.49e-07 3.3 5.49e-07 0 5.52e-07 0 5.52e-07 0 5.55e-07 0 5.55e-07 3.3 5.58e-07 3.3 5.58e-07 3.3 5.61e-07 3.3 5.611e-07 0 5.64e-07 0 5.641e-07 0 5.67e-07 0 5.671e-07 3.3 5.7e-07 3.3 5.701e-07 3.3 5.73e-07 3.3 5.73e-07 0 5.76e-07 0 5.76e-07 0 5.79e-07 0 5.79e-07 3.3 5.82e-07 3.3 5.821e-07 3.3 5.85e-07 3.3 5.851e-07 0 5.88e-07 0 5.881e-07 0 5.91e-07 0 5.911e-07 3.3 5.94e-07 3.3 5.94e-07 3.3 5.97e-07 3.3 5.97e-07 0 6e-07 0 6e-07 0 6.03e-07 0 6.03e-07 3.3 6.06e-07 3.3 6.061e-07 3.3 6.09e-07 3.3 6.091e-07 0 6.12e-07 0 6.121e-07 0 6.15e-07 0 6.151e-07 3.3 6.18e-07 3.3 6.18e-07 3.3 6.21e-07 3.3 6.21e-07 0 6.24e-07 0 6.24e-07 0 6.27e-07 0 6.27e-07 3.3 6.3e-07 3.3 6.301e-07 3.3 6.33e-07 3.3 6.331e-07 0 6.36e-07 0 6.361e-07 0 6.39e-07 0 6.391e-07 3.3 6.42e-07 3.3 6.42e-07 3.3 6.45e-07 3.3 6.45e-07 0 6.48e-07 0 6.48e-07 0 6.51e-07 0 6.51e-07 3.3 6.54e-07 3.3 6.541e-07 3.3 6.57e-07 3.3 6.571e-07 0 6.6e-07 0 6.601e-07 0 6.63e-07 0 6.631e-07 3.3 6.66e-07 3.3 6.66e-07 3.3 6.69e-07 3.3 6.69e-07 0 6.72e-07 0 6.72e-07 0 6.75e-07 0 6.75e-07 3.3 6.78e-07 3.3 6.781e-07 3.3 6.81e-07 3.3 6.811e-07 0 6.84e-07 0 6.841e-07 0 6.87e-07 0 6.87e-07 3.3 6.9e-07 3.3 6.9e-07 3.3 6.93e-07 3.3 6.93e-07 0 6.96e-07 0 6.96e-07 0 6.99e-07 0 6.991e-07 3.3 7.02e-07 3.3 7.021e-07 3.3 7.05e-07 3.3 7.051e-07 0 7.08e-07 0 7.081e-07 0 7.11e-07 0 7.11e-07 3.3 7.14e-07 3.3 7.14e-07 3.3 7.17e-07 3.3 7.17e-07 0 7.2e-07 0 7.2e-07 0 7.23e-07 0 7.231e-07 3.3 7.26e-07 3.3 7.261e-07 3.3 7.29e-07 3.3 7.291e-07 0 7.32e-07 0 7.321e-07 0 7.35e-07 0 7.35e-07 3.3 7.38e-07 3.3 7.38e-07 3.3 7.41e-07 3.3 7.41e-07 0 7.44e-07 0 7.44e-07 0 7.47e-07 0 7.471e-07 3.3 7.5e-07 3.3 7.501e-07 3.3 7.53e-07 3.3 7.531e-07 0 7.56e-07 0 7.561e-07 0 7.59e-07 0 7.59e-07 3.3 7.62e-07 3.3 7.62e-07 3.3 7.65e-07 3.3 7.65e-07 0 7.68e-07 0 7.68e-07 0 7.71e-07 0 7.711e-07 3.3 7.74e-07 3.3 7.741e-07 3.3 7.77e-07 3.3 7.771e-07 0 7.8e-07 0 7.8e-07 0 7.83e-07 0 7.83e-07 3.3 7.86e-07 3.3 7.86e-07 3.3 7.89e-07 3.3 7.89e-07 0 7.92e-07 0 7.921e-07 0 7.95e-07 0 7.951e-07 3.3 7.98e-07 3.3 7.981e-07 3.3 8.01e-07 3.3 8.011e-07 0 8.04e-07 0 8.04e-07 0 8.07e-07 0 8.07e-07 3.3 8.1e-07 3.3 8.1e-07 3.3 8.13e-07 3.3 8.13e-07 0 8.16e-07 0 8.161e-07 0 8.19e-07 0 8.191e-07 3.3 8.22e-07 3.3 8.221e-07 3.3 8.25e-07 3.3 8.251e-07 0 8.28e-07 0 8.28e-07 0 8.31e-07 0 8.31e-07 3.3 8.34e-07 3.3 8.34e-07 3.3 8.37e-07 3.3 8.37e-07 0 8.4e-07 0 8.401e-07 0 8.43e-07 0 8.431e-07 3.3 8.46e-07 3.3 8.461e-07 3.3 8.49e-07 3.3 8.491e-07 0 8.52e-07 0 8.52e-07 0 8.55e-07 0 8.55e-07 3.3 8.58e-07 3.3 8.58e-07 3.3 8.61e-07 3.3 8.61e-07 0 8.64e-07 0 8.641e-07 0 8.67e-07 0 8.671e-07 3.3 8.7e-07 3.3 8.701e-07 3.3 8.73e-07 3.3 8.73e-07 0 8.76e-07 0 8.76e-07 0 8.79e-07 0 8.79e-07 3.3 8.82e-07 3.3 8.82e-07 3.3 8.85e-07 3.3 8.851e-07 0 8.88e-07 0 8.881e-07 0 8.91e-07 0 8.911e-07 3.3 8.94e-07 3.3 8.941e-07 3.3 8.97e-07 3.3 8.97e-07 0 9e-07 0 9e-07 0 9.03e-07 0 9.03e-07 3.3 9.06e-07 3.3 9.06e-07 3.3 9.09e-07 3.3 9.091e-07 0 9.12e-07 0 9.121e-07 0 9.15e-07 0 9.151e-07 3.3 9.18e-07 3.3 9.181e-07 3.3 9.21e-07 3.3 9.21e-07 0 9.24e-07 0 9.24e-07 0 9.27e-07 0 9.27e-07 3.3 9.3e-07 3.3 9.3e-07 3.3 9.33e-07 3.3 9.331e-07 0 9.36e-07 0 9.361e-07 0 9.39e-07 0 9.391e-07 3.3 9.42e-07 3.3 9.421e-07 3.3 9.45e-07 3.3 9.45e-07 0 9.48e-07 0 9.48e-07 0 9.51e-07 0 9.51e-07 3.3 9.54e-07 3.3 9.54e-07 3.3 9.57e-07 3.3 9.57e-07 0 9.6e-07 0 9.6e-07 0 9.63e-07 0 9.63e-07 3.3 9.66e-07 3.3 9.66e-07 3.3 9.69e-07 3.3 9.69e-07 0 9.72e-07 0 9.72e-07 0 9.75e-07 0 9.75e-07 3.3 9.78e-07 3.3 9.78e-07 3.3 9.81e-07 3.3 9.81e-07 0 9.84e-07 0 9.84e-07 0 9.87e-07 0 9.87e-07 3.3 9.9e-07 3.3 9.9e-07 3.3 9.93e-07 3.3 9.93e-07 0 9.96e-07 0 9.96e-07 0 9.99e-07 0 9.99e-07 3.3 1.002e-06 3.3 1.002e-06 3.3 1.005e-06 3.3 1.005e-06 0 1.008e-06 0 1.008e-06 0 1.011e-06 0 1.011e-06 3.3 1.014e-06 3.3 1.014e-06 3.3 1.017e-06 3.3 1.017e-06 0 1.02e-06 0 1.02e-06 0 1.023e-06 0 1.023e-06 3.3 1.026e-06 3.3 1.026e-06 3.3 1.029e-06 3.3 1.029e-06 0 1.032e-06 0 1.032e-06 0 1.035e-06 0 1.035e-06 3.3 1.038e-06 3.3 1.038e-06 3.3 1.041e-06 3.3 1.041e-06 0 1.044e-06 0 1.044e-06 0 1.047e-06 0 1.047e-06 3.3 1.05e-06 3.3 1.05e-06 3.3 1.053e-06 3.3 1.053e-06 0 1.056e-06 0 1.056e-06 0 1.059e-06 0 1.059e-06 3.3 1.062e-06 3.3 1.062e-06 3.3 1.065e-06 3.3 1.065e-06 0 1.068e-06 0 1.068e-06 0 1.071e-06 0 1.071e-06 3.3 1.074e-06 3.3 1.074e-06 3.3 1.077e-06 3.3 1.077e-06 0 1.08e-06 0 1.08e-06 0 1.083e-06 0 1.083e-06 3.3 1.086e-06 3.3 1.086e-06 3.3 1.089e-06 3.3 1.089e-06 0 1.092e-06 0 1.092e-06 0 1.095e-06 0 1.095e-06 3.3 1.098e-06 3.3 1.098e-06 3.3 1.101e-06 3.3 1.101e-06 0 1.104e-06 0 1.104e-06 0 1.107e-06 0 1.107e-06 3.3 1.11e-06 3.3 1.11e-06 3.3 1.113e-06 3.3 1.113e-06 0 1.116e-06 0 1.116e-06 0 1.119e-06 0 1.119e-06 3.3 1.122e-06 3.3 1.122e-06 3.3 1.125e-06 3.3 1.125e-06 0 1.128e-06 0 1.128e-06 0 1.131e-06 0 1.131e-06 3.3 1.134e-06 3.3 1.134e-06 3.3 1.137e-06 3.3 1.137e-06 0 1.14e-06 0 1.14e-06 0 1.143e-06 0 1.143e-06 3.3 1.146e-06 3.3 1.146e-06 3.3 1.149e-06 3.3 1.149e-06 0 1.152e-06 0 1.152e-06 0 1.155e-06 0 1.155e-06 3.3 1.158e-06 3.3 1.158e-06 3.3 1.161e-06 3.3 1.161e-06 0 1.164e-06 0 1.164e-06 0 1.167e-06 0 1.167e-06 3.3 1.17e-06 3.3 1.17e-06 3.3 1.173e-06 3.3 1.173e-06 0 1.176e-06 0 1.176e-06 0 1.179e-06 0 1.179e-06 3.3 1.182e-06 3.3 1.182e-06 3.3 1.185e-06 3.3 1.185e-06 0 1.188e-06 0 1.188e-06 0 1.191e-06 0 1.191e-06 3.3 1.194e-06 3.3 1.194e-06 3.3 1.197e-06 3.3 1.197e-06 0 1.2e-06 0 1.2e-06 0 1.203e-06 0 1.203e-06 3.3 1.206e-06 3.3 1.206e-06 3.3 1.209e-06 3.3 1.209e-06 0 1.212e-06 0 1.212e-06 0 1.215e-06 0 1.215e-06 3.3 1.218e-06 3.3 1.218e-06 3.3 1.221e-06 3.3 1.221e-06 0 1.224e-06 0 1.224e-06 0 1.227e-06 0 1.227e-06 3.3 1.23e-06 3.3 1.23e-06 3.3 1.233e-06 3.3 1.233e-06 0 1.236e-06 0 1.236e-06 0 1.239e-06 0 1.239e-06 3.3 1.242e-06 3.3 1.242e-06 3.3 1.245e-06 3.3 1.245e-06 0 1.248e-06 0 1.248e-06 0 1.251e-06 0 1.251e-06 3.3 1.254e-06 3.3 1.254e-06 3.3 1.257e-06 3.3 1.257e-06 0 1.26e-06 0 1.26e-06 0 1.263e-06 0 1.263e-06 3.3 1.266e-06 3.3 1.266e-06 3.3 1.269e-06 3.3 1.269e-06 0 1.272e-06 0 1.272e-06 0 1.275e-06 0 1.275e-06 3.3 1.278e-06 3.3 1.278e-06 3.3 1.281e-06 3.3 1.281e-06 0 1.284e-06 0 1.284e-06 0 1.287e-06 0 1.287e-06 3.3 1.29e-06 3.3 1.29e-06 3.3 1.293e-06 3.3 1.293e-06 0 1.296e-06 0 1.296e-06 0 1.299e-06 0 1.299e-06 3.3 1.302e-06 3.3 1.302e-06 3.3 1.305e-06 3.3 1.305e-06 0 1.308e-06 0 1.308e-06 0 1.311e-06 0 1.311e-06 3.3 1.314e-06 3.3 1.314e-06 3.3 1.317e-06 3.3 1.317e-06 0 1.32e-06 0 1.32e-06 0 1.323e-06 0 1.323e-06 3.3 1.326e-06 3.3 1.326e-06 3.3 1.329e-06 3.3 1.329e-06 0 1.332e-06 0 1.332e-06 0 1.335e-06 0 1.335e-06 3.3 1.338e-06 3.3 1.338e-06 3.3 1.341e-06 3.3 1.341e-06 0 1.344e-06 0 1.344e-06 0 1.347e-06 0 1.347e-06 3.3 1.35e-06 3.3 1.35e-06 3.3 1.353e-06 3.3 1.353e-06 0 1.356e-06 0 1.356e-06 0 1.359e-06 0 1.359e-06 3.3 1.362e-06 3.3 1.362e-06 3.3 1.365e-06 3.3 1.365e-06 0 1.368e-06 0 1.368e-06 0 1.371e-06 0 1.371e-06 3.3 1.374e-06 3.3 1.374e-06 3.3 1.377e-06 3.3 1.377e-06 0 1.38e-06 0 1.38e-06 0 1.383e-06 0 1.383e-06 3.3 1.386e-06 3.3 1.386e-06 3.3 1.389e-06 3.3 1.389e-06 0 1.392e-06 0 1.392e-06 0 1.395e-06 0 1.395e-06 3.3 1.398e-06 3.3 1.398e-06 3.3 1.401e-06 3.3 1.401e-06 0 1.404e-06 0 1.404e-06 0 1.407e-06 0 1.407e-06 3.3 1.41e-06 3.3 1.41e-06 3.3 1.413e-06 3.3 1.413e-06 0 1.416e-06 0 1.416e-06 0 1.419e-06 0 1.419e-06 3.3 1.422e-06 3.3 1.422e-06 3.3 1.425e-06 3.3 1.425e-06 0 1.428e-06 0 1.428e-06 0 1.431e-06 0 1.431e-06 3.3 1.434e-06 3.3 1.434e-06 3.3 1.437e-06 3.3 1.437e-06 0 1.44e-06 0 1.44e-06 0 1.443e-06 0 1.443e-06 3.3 1.446e-06 3.3 1.446e-06 3.3 1.449e-06 3.3 1.449e-06 0 1.452e-06 0 1.452e-06 0 1.455e-06 0 1.455e-06 3.3 1.458e-06 3.3 1.458e-06 3.3 1.461e-06 3.3 1.461e-06 0 1.464e-06 0 1.464e-06 0 1.467e-06 0 1.467e-06 3.3 1.47e-06 3.3 1.47e-06 3.3 1.473e-06 3.3 1.473e-06 0 1.476e-06 0 1.476e-06 0 1.479e-06 0 1.479e-06 3.3 1.482e-06 3.3 1.482e-06 3.3 1.485e-06 3.3 1.485e-06 0 1.488e-06 0 1.488e-06 0 1.491e-06 0 1.491e-06 3.3 1.494e-06 3.3 1.494e-06 3.3 1.497e-06 3.3 1.497e-06 0 1.5e-06 0 1.5e-06 0 1.503e-06 0 1.503e-06 3.3 1.506e-06 3.3 1.506e-06 3.3 1.509e-06 3.3 1.509e-06 0 1.512e-06 0 1.512e-06 0 1.515e-06 0 1.515e-06 3.3 1.518e-06 3.3 1.518e-06 3.3 1.521e-06 3.3 1.521e-06 0 1.524e-06 0 1.524e-06 0 1.527e-06 0 1.527e-06 3.3 1.53e-06 3.3 1.53e-06 3.3 1.533e-06 3.3 1.533e-06 0)
VA1 A1 0 PWL(0 0 3e-09 0 3.05e-09 0 6e-09 0 6.05e-09 3.3 9e-09 3.3 9.05e-09 3.3 1.2e-08 3.3 1.205e-08 3.3 1.5e-08 3.3 1.505e-08 3.3 1.8e-08 3.3 1.805e-08 0 2.1e-08 0 2.105e-08 0 2.4e-08 0 2.405e-08 0 2.7e-08 0 2.705e-08 0 3e-08 0 3.005e-08 3.3 3.3e-08 3.3 3.305e-08 3.3 3.6e-08 3.3 3.605e-08 3.3 3.9e-08 3.3 3.905e-08 3.3 4.2e-08 3.3 4.205e-08 0 4.5e-08 0 4.505e-08 0 4.8e-08 0 4.805e-08 0 5.1e-08 0 5.105e-08 0 5.4e-08 0 5.405e-08 3.3 5.7e-08 3.3 5.705e-08 3.3 6e-08 3.3 6.005e-08 3.3 6.3e-08 3.3 6.305e-08 3.3 6.6e-08 3.3 6.605e-08 0 6.9e-08 0 6.905e-08 0 7.2e-08 0 7.205e-08 0 7.5e-08 0 7.505e-08 0 7.8e-08 0 7.805e-08 3.3 8.1e-08 3.3 8.105e-08 3.3 8.4e-08 3.3 8.405e-08 3.3 8.7e-08 3.3 8.705e-08 3.3 9e-08 3.3 9.005e-08 0 9.3e-08 0 9.305e-08 0 9.6e-08 0 9.605e-08 0 9.9e-08 0 9.905e-08 0 1.02e-07 0 1.021e-07 3.3 1.05e-07 3.3 1.051e-07 3.3 1.08e-07 3.3 1.081e-07 3.3 1.11e-07 3.3 1.111e-07 3.3 1.14e-07 3.3 1.141e-07 0 1.17e-07 0 1.171e-07 0 1.2e-07 0 1.2e-07 0 1.23e-07 0 1.231e-07 0 1.26e-07 0 1.26e-07 3.3 1.29e-07 3.3 1.291e-07 3.3 1.32e-07 3.3 1.32e-07 3.3 1.35e-07 3.3 1.351e-07 3.3 1.38e-07 3.3 1.38e-07 0 1.41e-07 0 1.411e-07 0 1.44e-07 0 1.44e-07 0 1.47e-07 0 1.471e-07 0 1.5e-07 0 1.5e-07 3.3 1.53e-07 3.3 1.531e-07 3.3 1.56e-07 3.3 1.56e-07 3.3 1.59e-07 3.3 1.591e-07 3.3 1.62e-07 3.3 1.62e-07 0 1.65e-07 0 1.651e-07 0 1.68e-07 0 1.68e-07 0 1.71e-07 0 1.711e-07 0 1.74e-07 0 1.741e-07 3.3 1.77e-07 3.3 1.771e-07 3.3 1.8e-07 3.3 1.801e-07 3.3 1.83e-07 3.3 1.831e-07 3.3 1.86e-07 3.3 1.861e-07 0 1.89e-07 0 1.891e-07 0 1.92e-07 0 1.921e-07 0 1.95e-07 0 1.95e-07 0 1.98e-07 0 1.981e-07 3.3 2.01e-07 3.3 2.01e-07 3.3 2.04e-07 3.3 2.041e-07 3.3 2.07e-07 3.3 2.07e-07 3.3 2.1e-07 3.3 2.101e-07 0 2.13e-07 0 2.13e-07 0 2.16e-07 0 2.161e-07 0 2.19e-07 0 2.19e-07 0 2.22e-07 0 2.221e-07 3.3 2.25e-07 3.3 2.25e-07 3.3 2.28e-07 3.3 2.281e-07 3.3 2.31e-07 3.3 2.31e-07 3.3 2.34e-07 3.3 2.341e-07 0 2.37e-07 0 2.37e-07 0 2.4e-07 0 2.4e-07 0 2.43e-07 0 2.43e-07 0 2.46e-07 0 2.461e-07 3.3 2.49e-07 3.3 2.491e-07 3.3 2.52e-07 3.3 2.52e-07 3.3 2.55e-07 3.3 2.55e-07 3.3 2.58e-07 3.3 2.581e-07 0 2.61e-07 0 2.611e-07 0 2.64e-07 0 2.64e-07 0 2.67e-07 0 2.67e-07 0 2.7e-07 0 2.701e-07 3.3 2.73e-07 3.3 2.731e-07 3.3 2.76e-07 3.3 2.76e-07 3.3 2.79e-07 3.3 2.791e-07 3.3 2.82e-07 3.3 2.821e-07 0 2.85e-07 0 2.851e-07 0 2.88e-07 0 2.88e-07 0 2.91e-07 0 2.911e-07 0 2.94e-07 0 2.941e-07 3.3 2.97e-07 3.3 2.97e-07 3.3 3e-07 3.3 3e-07 3.3 3.03e-07 3.3 3.031e-07 3.3 3.06e-07 3.3 3.061e-07 0 3.09e-07 0 3.09e-07 0 3.12e-07 0 3.12e-07 0 3.15e-07 0 3.151e-07 0 3.18e-07 0 3.181e-07 3.3 3.21e-07 3.3 3.21e-07 3.3 3.24e-07 3.3 3.24e-07 3.3 3.27e-07 3.3 3.271e-07 3.3 3.3e-07 3.3 3.301e-07 0 3.33e-07 0 3.33e-07 0 3.36e-07 0 3.36e-07 0 3.39e-07 0 3.391e-07 0 3.42e-07 0 3.421e-07 3.3 3.45e-07 3.3 3.45e-07 3.3 3.48e-07 3.3 3.48e-07 3.3 3.51e-07 3.3 3.511e-07 3.3 3.54e-07 3.3 3.541e-07 0 3.57e-07 0 3.57e-07 0 3.6e-07 0 3.6e-07 0 3.63e-07 0 3.631e-07 0 3.66e-07 0 3.661e-07 3.3 3.69e-07 3.3 3.69e-07 3.3 3.72e-07 3.3 3.72e-07 3.3 3.75e-07 3.3 3.751e-07 3.3 3.78e-07 3.3 3.781e-07 0 3.81e-07 0 3.81e-07 0 3.84e-07 0 3.841e-07 0 3.87e-07 0 3.871e-07 0 3.9e-07 0 3.9e-07 3.3 3.93e-07 3.3 3.93e-07 3.3 3.96e-07 3.3 3.961e-07 3.3 3.99e-07 3.3 3.991e-07 3.3 4.02e-07 3.3 4.02e-07 0 4.05e-07 0 4.05e-07 0 4.08e-07 0 4.081e-07 0 4.11e-07 0 4.111e-07 0 4.14e-07 0 4.14e-07 3.3 4.17e-07 3.3 4.17e-07 3.3 4.2e-07 3.3 4.201e-07 3.3 4.23e-07 3.3 4.231e-07 3.3 4.26e-07 3.3 4.26e-07 0 4.29e-07 0 4.29e-07 0 4.32e-07 0 4.321e-07 0 4.35e-07 0 4.351e-07 0 4.38e-07 0 4.38e-07 3.3 4.41e-07 3.3 4.41e-07 3.3 4.44e-07 3.3 4.441e-07 3.3 4.47e-07 3.3 4.471e-07 3.3 4.5e-07 3.3 4.5e-07 0 4.53e-07 0 4.53e-07 0 4.56e-07 0 4.561e-07 0 4.59e-07 0 4.591e-07 0 4.62e-07 0 4.62e-07 3.3 4.65e-07 3.3 4.65e-07 3.3 4.68e-07 3.3 4.681e-07 3.3 4.71e-07 3.3 4.711e-07 3.3 4.74e-07 3.3 4.74e-07 0 4.77e-07 0 4.771e-07 0 4.8e-07 0 4.8e-07 0 4.83e-07 0 4.83e-07 0 4.86e-07 0 4.86e-07 3.3 4.89e-07 3.3 4.891e-07 3.3 4.92e-07 3.3 4.921e-07 3.3 4.95e-07 3.3 4.951e-07 3.3 4.98e-07 3.3 4.981e-07 0 5.01e-07 0 5.01e-07 0 5.04e-07 0 5.04e-07 0 5.07e-07 0 5.07e-07 0 5.1e-07 0 5.1e-07 3.3 5.13e-07 3.3 5.131e-07 3.3 5.16e-07 3.3 5.161e-07 3.3 5.19e-07 3.3 5.191e-07 3.3 5.22e-07 3.3 5.221e-07 0 5.25e-07 0 5.25e-07 0 5.28e-07 0 5.28e-07 0 5.31e-07 0 5.31e-07 0 5.34e-07 0 5.34e-07 3.3 5.37e-07 3.3 5.371e-07 3.3 5.4e-07 3.3 5.401e-07 3.3 5.43e-07 3.3 5.431e-07 3.3 5.46e-07 3.3 5.461e-07 0 5.49e-07 0 5.49e-07 0 5.52e-07 0 5.52e-07 0 5.55e-07 0 5.55e-07 0 5.58e-07 0 5.58e-07 3.3 5.61e-07 3.3 5.611e-07 3.3 5.64e-07 3.3 5.641e-07 3.3 5.67e-07 3.3 5.671e-07 3.3 5.7e-07 3.3 5.701e-07 0 5.73e-07 0 5.73e-07 0 5.76e-07 0 5.76e-07 0 5.79e-07 0 5.79e-07 0 5.82e-07 0 5.821e-07 3.3 5.85e-07 3.3 5.851e-07 3.3 5.88e-07 3.3 5.881e-07 3.3 5.91e-07 3.3 5.911e-07 3.3 5.94e-07 3.3 5.94e-07 0 5.97e-07 0 5.97e-07 0 6e-07 0 6e-07 0 6.03e-07 0 6.03e-07 0 6.06e-07 0 6.061e-07 3.3 6.09e-07 3.3 6.091e-07 3.3 6.12e-07 3.3 6.121e-07 3.3 6.15e-07 3.3 6.151e-07 3.3 6.18e-07 3.3 6.18e-07 0 6.21e-07 0 6.21e-07 0 6.24e-07 0 6.24e-07 0 6.27e-07 0 6.27e-07 0 6.3e-07 0 6.301e-07 3.3 6.33e-07 3.3 6.331e-07 3.3 6.36e-07 3.3 6.361e-07 3.3 6.39e-07 3.3 6.391e-07 3.3 6.42e-07 3.3 6.42e-07 0 6.45e-07 0 6.45e-07 0 6.48e-07 0 6.48e-07 0 6.51e-07 0 6.51e-07 0 6.54e-07 0 6.541e-07 3.3 6.57e-07 3.3 6.571e-07 3.3 6.6e-07 3.3 6.601e-07 3.3 6.63e-07 3.3 6.631e-07 3.3 6.66e-07 3.3 6.66e-07 0 6.69e-07 0 6.69e-07 0 6.72e-07 0 6.72e-07 0 6.75e-07 0 6.75e-07 0 6.78e-07 0 6.781e-07 3.3 6.81e-07 3.3 6.811e-07 3.3 6.84e-07 3.3 6.841e-07 3.3 6.87e-07 3.3 6.87e-07 3.3 6.9e-07 3.3 6.9e-07 0 6.93e-07 0 6.93e-07 0 6.96e-07 0 6.96e-07 0 6.99e-07 0 6.991e-07 0 7.02e-07 0 7.021e-07 3.3 7.05e-07 3.3 7.051e-07 3.3 7.08e-07 3.3 7.081e-07 3.3 7.11e-07 3.3 7.11e-07 3.3 7.14e-07 3.3 7.14e-07 0 7.17e-07 0 7.17e-07 0 7.2e-07 0 7.2e-07 0 7.23e-07 0 7.231e-07 0 7.26e-07 0 7.261e-07 3.3 7.29e-07 3.3 7.291e-07 3.3 7.32e-07 3.3 7.321e-07 3.3 7.35e-07 3.3 7.35e-07 3.3 7.38e-07 3.3 7.38e-07 0 7.41e-07 0 7.41e-07 0 7.44e-07 0 7.44e-07 0 7.47e-07 0 7.471e-07 0 7.5e-07 0 7.501e-07 3.3 7.53e-07 3.3 7.531e-07 3.3 7.56e-07 3.3 7.561e-07 3.3 7.59e-07 3.3 7.59e-07 3.3 7.62e-07 3.3 7.62e-07 0 7.65e-07 0 7.65e-07 0 7.68e-07 0 7.68e-07 0 7.71e-07 0 7.711e-07 0 7.74e-07 0 7.741e-07 3.3 7.77e-07 3.3 7.771e-07 3.3 7.8e-07 3.3 7.8e-07 3.3 7.83e-07 3.3 7.83e-07 3.3 7.86e-07 3.3 7.86e-07 0 7.89e-07 0 7.89e-07 0 7.92e-07 0 7.921e-07 0 7.95e-07 0 7.951e-07 0 7.98e-07 0 7.981e-07 3.3 8.01e-07 3.3 8.011e-07 3.3 8.04e-07 3.3 8.04e-07 3.3 8.07e-07 3.3 8.07e-07 3.3 8.1e-07 3.3 8.1e-07 0 8.13e-07 0 8.13e-07 0 8.16e-07 0 8.161e-07 0 8.19e-07 0 8.191e-07 0 8.22e-07 0 8.221e-07 3.3 8.25e-07 3.3 8.251e-07 3.3 8.28e-07 3.3 8.28e-07 3.3 8.31e-07 3.3 8.31e-07 3.3 8.34e-07 3.3 8.34e-07 0 8.37e-07 0 8.37e-07 0 8.4e-07 0 8.401e-07 0 8.43e-07 0 8.431e-07 0 8.46e-07 0 8.461e-07 3.3 8.49e-07 3.3 8.491e-07 3.3 8.52e-07 3.3 8.52e-07 3.3 8.55e-07 3.3 8.55e-07 3.3 8.58e-07 3.3 8.58e-07 0 8.61e-07 0 8.61e-07 0 8.64e-07 0 8.641e-07 0 8.67e-07 0 8.671e-07 0 8.7e-07 0 8.701e-07 3.3 8.73e-07 3.3 8.73e-07 3.3 8.76e-07 3.3 8.76e-07 3.3 8.79e-07 3.3 8.79e-07 3.3 8.82e-07 3.3 8.82e-07 0 8.85e-07 0 8.851e-07 0 8.88e-07 0 8.881e-07 0 8.91e-07 0 8.911e-07 0 8.94e-07 0 8.941e-07 3.3 8.97e-07 3.3 8.97e-07 3.3 9e-07 3.3 9e-07 3.3 9.03e-07 3.3 9.03e-07 3.3 9.06e-07 3.3 9.06e-07 0 9.09e-07 0 9.091e-07 0 9.12e-07 0 9.121e-07 0 9.15e-07 0 9.151e-07 0 9.18e-07 0 9.181e-07 3.3 9.21e-07 3.3 9.21e-07 3.3 9.24e-07 3.3 9.24e-07 3.3 9.27e-07 3.3 9.27e-07 3.3 9.3e-07 3.3 9.3e-07 0 9.33e-07 0 9.331e-07 0 9.36e-07 0 9.361e-07 0 9.39e-07 0 9.391e-07 0 9.42e-07 0 9.421e-07 3.3 9.45e-07 3.3 9.45e-07 3.3 9.48e-07 3.3 9.48e-07 3.3 9.51e-07 3.3 9.51e-07 3.3 9.54e-07 3.3 9.54e-07 0 9.57e-07 0 9.57e-07 0 9.6e-07 0 9.6e-07 0 9.63e-07 0 9.63e-07 0 9.66e-07 0 9.66e-07 3.3 9.69e-07 3.3 9.69e-07 3.3 9.72e-07 3.3 9.72e-07 3.3 9.75e-07 3.3 9.75e-07 3.3 9.78e-07 3.3 9.78e-07 0 9.81e-07 0 9.81e-07 0 9.84e-07 0 9.84e-07 0 9.87e-07 0 9.87e-07 0 9.9e-07 0 9.9e-07 3.3 9.93e-07 3.3 9.93e-07 3.3 9.96e-07 3.3 9.96e-07 3.3 9.99e-07 3.3 9.99e-07 3.3 1.002e-06 3.3 1.002e-06 0 1.005e-06 0 1.005e-06 0 1.008e-06 0 1.008e-06 0 1.011e-06 0 1.011e-06 0 1.014e-06 0 1.014e-06 3.3 1.017e-06 3.3 1.017e-06 3.3 1.02e-06 3.3 1.02e-06 3.3 1.023e-06 3.3 1.023e-06 3.3 1.026e-06 3.3 1.026e-06 0 1.029e-06 0 1.029e-06 0 1.032e-06 0 1.032e-06 0 1.035e-06 0 1.035e-06 0 1.038e-06 0 1.038e-06 3.3 1.041e-06 3.3 1.041e-06 3.3 1.044e-06 3.3 1.044e-06 3.3 1.047e-06 3.3 1.047e-06 3.3 1.05e-06 3.3 1.05e-06 0 1.053e-06 0 1.053e-06 0 1.056e-06 0 1.056e-06 0 1.059e-06 0 1.059e-06 0 1.062e-06 0 1.062e-06 3.3 1.065e-06 3.3 1.065e-06 3.3 1.068e-06 3.3 1.068e-06 3.3 1.071e-06 3.3 1.071e-06 3.3 1.074e-06 3.3 1.074e-06 0 1.077e-06 0 1.077e-06 0 1.08e-06 0 1.08e-06 0 1.083e-06 0 1.083e-06 0 1.086e-06 0 1.086e-06 3.3 1.089e-06 3.3 1.089e-06 3.3 1.092e-06 3.3 1.092e-06 3.3 1.095e-06 3.3 1.095e-06 3.3 1.098e-06 3.3 1.098e-06 0 1.101e-06 0 1.101e-06 0 1.104e-06 0 1.104e-06 0 1.107e-06 0 1.107e-06 0 1.11e-06 0 1.11e-06 3.3 1.113e-06 3.3 1.113e-06 3.3 1.116e-06 3.3 1.116e-06 3.3 1.119e-06 3.3 1.119e-06 3.3 1.122e-06 3.3 1.122e-06 0 1.125e-06 0 1.125e-06 0 1.128e-06 0 1.128e-06 0 1.131e-06 0 1.131e-06 0 1.134e-06 0 1.134e-06 3.3 1.137e-06 3.3 1.137e-06 3.3 1.14e-06 3.3 1.14e-06 3.3 1.143e-06 3.3 1.143e-06 3.3 1.146e-06 3.3 1.146e-06 0 1.149e-06 0 1.149e-06 0 1.152e-06 0 1.152e-06 0 1.155e-06 0 1.155e-06 0 1.158e-06 0 1.158e-06 3.3 1.161e-06 3.3 1.161e-06 3.3 1.164e-06 3.3 1.164e-06 3.3 1.167e-06 3.3 1.167e-06 3.3 1.17e-06 3.3 1.17e-06 0 1.173e-06 0 1.173e-06 0 1.176e-06 0 1.176e-06 0 1.179e-06 0 1.179e-06 0 1.182e-06 0 1.182e-06 3.3 1.185e-06 3.3 1.185e-06 3.3 1.188e-06 3.3 1.188e-06 3.3 1.191e-06 3.3 1.191e-06 3.3 1.194e-06 3.3 1.194e-06 0 1.197e-06 0 1.197e-06 0 1.2e-06 0 1.2e-06 0 1.203e-06 0 1.203e-06 0 1.206e-06 0 1.206e-06 3.3 1.209e-06 3.3 1.209e-06 3.3 1.212e-06 3.3 1.212e-06 3.3 1.215e-06 3.3 1.215e-06 3.3 1.218e-06 3.3 1.218e-06 0 1.221e-06 0 1.221e-06 0 1.224e-06 0 1.224e-06 0 1.227e-06 0 1.227e-06 0 1.23e-06 0 1.23e-06 3.3 1.233e-06 3.3 1.233e-06 3.3 1.236e-06 3.3 1.236e-06 3.3 1.239e-06 3.3 1.239e-06 3.3 1.242e-06 3.3 1.242e-06 0 1.245e-06 0 1.245e-06 0 1.248e-06 0 1.248e-06 0 1.251e-06 0 1.251e-06 0 1.254e-06 0 1.254e-06 3.3 1.257e-06 3.3 1.257e-06 3.3 1.26e-06 3.3 1.26e-06 3.3 1.263e-06 3.3 1.263e-06 3.3 1.266e-06 3.3 1.266e-06 0 1.269e-06 0 1.269e-06 0 1.272e-06 0 1.272e-06 0 1.275e-06 0 1.275e-06 0 1.278e-06 0 1.278e-06 3.3 1.281e-06 3.3 1.281e-06 3.3 1.284e-06 3.3 1.284e-06 3.3 1.287e-06 3.3 1.287e-06 3.3 1.29e-06 3.3 1.29e-06 0 1.293e-06 0 1.293e-06 0 1.296e-06 0 1.296e-06 0 1.299e-06 0 1.299e-06 0 1.302e-06 0 1.302e-06 3.3 1.305e-06 3.3 1.305e-06 3.3 1.308e-06 3.3 1.308e-06 3.3 1.311e-06 3.3 1.311e-06 3.3 1.314e-06 3.3 1.314e-06 0 1.317e-06 0 1.317e-06 0 1.32e-06 0 1.32e-06 0 1.323e-06 0 1.323e-06 0 1.326e-06 0 1.326e-06 3.3 1.329e-06 3.3 1.329e-06 3.3 1.332e-06 3.3 1.332e-06 3.3 1.335e-06 3.3 1.335e-06 3.3 1.338e-06 3.3 1.338e-06 0 1.341e-06 0 1.341e-06 0 1.344e-06 0 1.344e-06 0 1.347e-06 0 1.347e-06 0 1.35e-06 0 1.35e-06 3.3 1.353e-06 3.3 1.353e-06 3.3 1.356e-06 3.3 1.356e-06 3.3 1.359e-06 3.3 1.359e-06 3.3 1.362e-06 3.3 1.362e-06 0 1.365e-06 0 1.365e-06 0 1.368e-06 0 1.368e-06 0 1.371e-06 0 1.371e-06 0 1.374e-06 0 1.374e-06 3.3 1.377e-06 3.3 1.377e-06 3.3 1.38e-06 3.3 1.38e-06 3.3 1.383e-06 3.3 1.383e-06 3.3 1.386e-06 3.3 1.386e-06 0 1.389e-06 0 1.389e-06 0 1.392e-06 0 1.392e-06 0 1.395e-06 0 1.395e-06 0 1.398e-06 0 1.398e-06 3.3 1.401e-06 3.3 1.401e-06 3.3 1.404e-06 3.3 1.404e-06 3.3 1.407e-06 3.3 1.407e-06 3.3 1.41e-06 3.3 1.41e-06 0 1.413e-06 0 1.413e-06 0 1.416e-06 0 1.416e-06 0 1.419e-06 0 1.419e-06 0 1.422e-06 0 1.422e-06 3.3 1.425e-06 3.3 1.425e-06 3.3 1.428e-06 3.3 1.428e-06 3.3 1.431e-06 3.3 1.431e-06 3.3 1.434e-06 3.3 1.434e-06 0 1.437e-06 0 1.437e-06 0 1.44e-06 0 1.44e-06 0 1.443e-06 0 1.443e-06 0 1.446e-06 0 1.446e-06 3.3 1.449e-06 3.3 1.449e-06 3.3 1.452e-06 3.3 1.452e-06 3.3 1.455e-06 3.3 1.455e-06 3.3 1.458e-06 3.3 1.458e-06 0 1.461e-06 0 1.461e-06 0 1.464e-06 0 1.464e-06 0 1.467e-06 0 1.467e-06 0 1.47e-06 0 1.47e-06 3.3 1.473e-06 3.3 1.473e-06 3.3 1.476e-06 3.3 1.476e-06 3.3 1.479e-06 3.3 1.479e-06 3.3 1.482e-06 3.3 1.482e-06 0 1.485e-06 0 1.485e-06 0 1.488e-06 0 1.488e-06 0 1.491e-06 0 1.491e-06 0 1.494e-06 0 1.494e-06 3.3 1.497e-06 3.3 1.497e-06 3.3 1.5e-06 3.3 1.5e-06 3.3 1.503e-06 3.3 1.503e-06 3.3 1.506e-06 3.3 1.506e-06 0 1.509e-06 0 1.509e-06 0 1.512e-06 0 1.512e-06 0 1.515e-06 0 1.515e-06 0 1.518e-06 0 1.518e-06 3.3 1.521e-06 3.3 1.521e-06 3.3 1.524e-06 3.3 1.524e-06 3.3 1.527e-06 3.3 1.527e-06 3.3 1.53e-06 3.3 1.53e-06 0 1.533e-06 0 1.533e-06 0)
VA2 A2 0 PWL(0 0 3e-09 0 3.05e-09 0 6e-09 0 6.05e-09 0 9e-09 0 9.05e-09 0 1.2e-08 0 1.205e-08 3.3 1.5e-08 3.3 1.505e-08 3.3 1.8e-08 3.3 1.805e-08 3.3 2.1e-08 3.3 2.105e-08 3.3 2.4e-08 3.3 2.405e-08 3.3 2.7e-08 3.3 2.705e-08 3.3 3e-08 3.3 3.005e-08 3.3 3.3e-08 3.3 3.305e-08 3.3 3.6e-08 3.3 3.605e-08 0 3.9e-08 0 3.905e-08 0 4.2e-08 0 4.205e-08 0 4.5e-08 0 4.505e-08 0 4.8e-08 0 4.805e-08 0 5.1e-08 0 5.105e-08 0 5.4e-08 0 5.405e-08 0 5.7e-08 0 5.705e-08 0 6e-08 0 6.005e-08 3.3 6.3e-08 3.3 6.305e-08 3.3 6.6e-08 3.3 6.605e-08 3.3 6.9e-08 3.3 6.905e-08 3.3 7.2e-08 3.3 7.205e-08 3.3 7.5e-08 3.3 7.505e-08 3.3 7.8e-08 3.3 7.805e-08 3.3 8.1e-08 3.3 8.105e-08 3.3 8.4e-08 3.3 8.405e-08 0 8.7e-08 0 8.705e-08 0 9e-08 0 9.005e-08 0 9.3e-08 0 9.305e-08 0 9.6e-08 0 9.605e-08 0 9.9e-08 0 9.905e-08 0 1.02e-07 0 1.021e-07 0 1.05e-07 0 1.051e-07 0 1.08e-07 0 1.081e-07 3.3 1.11e-07 3.3 1.111e-07 3.3 1.14e-07 3.3 1.141e-07 3.3 1.17e-07 3.3 1.171e-07 3.3 1.2e-07 3.3 1.2e-07 3.3 1.23e-07 3.3 1.231e-07 3.3 1.26e-07 3.3 1.26e-07 3.3 1.29e-07 3.3 1.291e-07 3.3 1.32e-07 3.3 1.32e-07 0 1.35e-07 0 1.351e-07 0 1.38e-07 0 1.38e-07 0 1.41e-07 0 1.411e-07 0 1.44e-07 0 1.44e-07 0 1.47e-07 0 1.471e-07 0 1.5e-07 0 1.5e-07 0 1.53e-07 0 1.531e-07 0 1.56e-07 0 1.56e-07 3.3 1.59e-07 3.3 1.591e-07 3.3 1.62e-07 3.3 1.62e-07 3.3 1.65e-07 3.3 1.651e-07 3.3 1.68e-07 3.3 1.68e-07 3.3 1.71e-07 3.3 1.711e-07 3.3 1.74e-07 3.3 1.741e-07 3.3 1.77e-07 3.3 1.771e-07 3.3 1.8e-07 3.3 1.801e-07 0 1.83e-07 0 1.831e-07 0 1.86e-07 0 1.861e-07 0 1.89e-07 0 1.891e-07 0 1.92e-07 0 1.921e-07 0 1.95e-07 0 1.95e-07 0 1.98e-07 0 1.981e-07 0 2.01e-07 0 2.01e-07 0 2.04e-07 0 2.041e-07 3.3 2.07e-07 3.3 2.07e-07 3.3 2.1e-07 3.3 2.101e-07 3.3 2.13e-07 3.3 2.13e-07 3.3 2.16e-07 3.3 2.161e-07 3.3 2.19e-07 3.3 2.19e-07 3.3 2.22e-07 3.3 2.221e-07 3.3 2.25e-07 3.3 2.25e-07 3.3 2.28e-07 3.3 2.281e-07 0 2.31e-07 0 2.31e-07 0 2.34e-07 0 2.341e-07 0 2.37e-07 0 2.37e-07 0 2.4e-07 0 2.4e-07 0 2.43e-07 0 2.43e-07 0 2.46e-07 0 2.461e-07 0 2.49e-07 0 2.491e-07 0 2.52e-07 0 2.52e-07 3.3 2.55e-07 3.3 2.55e-07 3.3 2.58e-07 3.3 2.581e-07 3.3 2.61e-07 3.3 2.611e-07 3.3 2.64e-07 3.3 2.64e-07 3.3 2.67e-07 3.3 2.67e-07 3.3 2.7e-07 3.3 2.701e-07 3.3 2.73e-07 3.3 2.731e-07 3.3 2.76e-07 3.3 2.76e-07 0 2.79e-07 0 2.791e-07 0 2.82e-07 0 2.821e-07 0 2.85e-07 0 2.851e-07 0 2.88e-07 0 2.88e-07 0 2.91e-07 0 2.911e-07 0 2.94e-07 0 2.941e-07 0 2.97e-07 0 2.97e-07 0 3e-07 0 3e-07 3.3 3.03e-07 3.3 3.031e-07 3.3 3.06e-07 3.3 3.061e-07 3.3 3.09e-07 3.3 3.09e-07 3.3 3.12e-07 3.3 3.12e-07 3.3 3.15e-07 3.3 3.151e-07 3.3 3.18e-07 3.3 3.181e-07 3.3 3.21e-07 3.3 3.21e-07 3.3 3.24e-07 3.3 3.24e-07 0 3.27e-07 0 3.271e-07 0 3.3e-07 0 3.301e-07 0 3.33e-07 0 3.33e-07 0 3.36e-07 0 3.36e-07 0 3.39e-07 0 3.391e-07 0 3.42e-07 0 3.421e-07 0 3.45e-07 0 3.45e-07 0 3.48e-07 0 3.48e-07 3.3 3.51e-07 3.3 3.511e-07 3.3 3.54e-07 3.3 3.541e-07 3.3 3.57e-07 3.3 3.57e-07 3.3 3.6e-07 3.3 3.6e-07 3.3 3.63e-07 3.3 3.631e-07 3.3 3.66e-07 3.3 3.661e-07 3.3 3.69e-07 3.3 3.69e-07 3.3 3.72e-07 3.3 3.72e-07 0 3.75e-07 0 3.751e-07 0 3.78e-07 0 3.781e-07 0 3.81e-07 0 3.81e-07 0 3.84e-07 0 3.841e-07 0 3.87e-07 0 3.871e-07 0 3.9e-07 0 3.9e-07 0 3.93e-07 0 3.93e-07 0 3.96e-07 0 3.961e-07 3.3 3.99e-07 3.3 3.991e-07 3.3 4.02e-07 3.3 4.02e-07 3.3 4.05e-07 3.3 4.05e-07 3.3 4.08e-07 3.3 4.081e-07 3.3 4.11e-07 3.3 4.111e-07 3.3 4.14e-07 3.3 4.14e-07 3.3 4.17e-07 3.3 4.17e-07 3.3 4.2e-07 3.3 4.201e-07 0 4.23e-07 0 4.231e-07 0 4.26e-07 0 4.26e-07 0 4.29e-07 0 4.29e-07 0 4.32e-07 0 4.321e-07 0 4.35e-07 0 4.351e-07 0 4.38e-07 0 4.38e-07 0 4.41e-07 0 4.41e-07 0 4.44e-07 0 4.441e-07 3.3 4.47e-07 3.3 4.471e-07 3.3 4.5e-07 3.3 4.5e-07 3.3 4.53e-07 3.3 4.53e-07 3.3 4.56e-07 3.3 4.561e-07 3.3 4.59e-07 3.3 4.591e-07 3.3 4.62e-07 3.3 4.62e-07 3.3 4.65e-07 3.3 4.65e-07 3.3 4.68e-07 3.3 4.681e-07 0 4.71e-07 0 4.711e-07 0 4.74e-07 0 4.74e-07 0 4.77e-07 0 4.771e-07 0 4.8e-07 0 4.8e-07 0 4.83e-07 0 4.83e-07 0 4.86e-07 0 4.86e-07 0 4.89e-07 0 4.891e-07 0 4.92e-07 0 4.921e-07 3.3 4.95e-07 3.3 4.951e-07 3.3 4.98e-07 3.3 4.981e-07 3.3 5.01e-07 3.3 5.01e-07 3.3 5.04e-07 3.3 5.04e-07 3.3 5.07e-07 3.3 5.07e-07 3.3 5.1e-07 3.3 5.1e-07 3.3 5.13e-07 3.3 5.131e-07 3.3 5.16e-07 3.3 5.161e-07 0 5.19e-07 0 5.191e-07 0 5.22e-07 0 5.221e-07 0 5.25e-07 0 5.25e-07 0 5.28e-07 0 5.28e-07 0 5.31e-07 0 5.31e-07 0 5.34e-07 0 5.34e-07 0 5.37e-07 0 5.371e-07 0 5.4e-07 0 5.401e-07 3.3 5.43e-07 3.3 5.431e-07 3.3 5.46e-07 3.3 5.461e-07 3.3 5.49e-07 3.3 5.49e-07 3.3 5.52e-07 3.3 5.52e-07 3.3 5.55e-07 3.3 5.55e-07 3.3 5.58e-07 3.3 5.58e-07 3.3 5.61e-07 3.3 5.611e-07 3.3 5.64e-07 3.3 5.641e-07 0 5.67e-07 0 5.671e-07 0 5.7e-07 0 5.701e-07 0 5.73e-07 0 5.73e-07 0 5.76e-07 0 5.76e-07 0 5.79e-07 0 5.79e-07 0 5.82e-07 0 5.821e-07 0 5.85e-07 0 5.851e-07 0 5.88e-07 0 5.881e-07 3.3 5.91e-07 3.3 5.911e-07 3.3 5.94e-07 3.3 5.94e-07 3.3 5.97e-07 3.3 5.97e-07 3.3 6e-07 3.3 6e-07 3.3 6.03e-07 3.3 6.03e-07 3.3 6.06e-07 3.3 6.061e-07 3.3 6.09e-07 3.3 6.091e-07 3.3 6.12e-07 3.3 6.121e-07 0 6.15e-07 0 6.151e-07 0 6.18e-07 0 6.18e-07 0 6.21e-07 0 6.21e-07 0 6.24e-07 0 6.24e-07 0 6.27e-07 0 6.27e-07 0 6.3e-07 0 6.301e-07 0 6.33e-07 0 6.331e-07 0 6.36e-07 0 6.361e-07 3.3 6.39e-07 3.3 6.391e-07 3.3 6.42e-07 3.3 6.42e-07 3.3 6.45e-07 3.3 6.45e-07 3.3 6.48e-07 3.3 6.48e-07 3.3 6.51e-07 3.3 6.51e-07 3.3 6.54e-07 3.3 6.541e-07 3.3 6.57e-07 3.3 6.571e-07 3.3 6.6e-07 3.3 6.601e-07 0 6.63e-07 0 6.631e-07 0 6.66e-07 0 6.66e-07 0 6.69e-07 0 6.69e-07 0 6.72e-07 0 6.72e-07 0 6.75e-07 0 6.75e-07 0 6.78e-07 0 6.781e-07 0 6.81e-07 0 6.811e-07 0 6.84e-07 0 6.841e-07 3.3 6.87e-07 3.3 6.87e-07 3.3 6.9e-07 3.3 6.9e-07 3.3 6.93e-07 3.3 6.93e-07 3.3 6.96e-07 3.3 6.96e-07 3.3 6.99e-07 3.3 6.991e-07 3.3 7.02e-07 3.3 7.021e-07 3.3 7.05e-07 3.3 7.051e-07 3.3 7.08e-07 3.3 7.081e-07 0 7.11e-07 0 7.11e-07 0 7.14e-07 0 7.14e-07 0 7.17e-07 0 7.17e-07 0 7.2e-07 0 7.2e-07 0 7.23e-07 0 7.231e-07 0 7.26e-07 0 7.261e-07 0 7.29e-07 0 7.291e-07 0 7.32e-07 0 7.321e-07 3.3 7.35e-07 3.3 7.35e-07 3.3 7.38e-07 3.3 7.38e-07 3.3 7.41e-07 3.3 7.41e-07 3.3 7.44e-07 3.3 7.44e-07 3.3 7.47e-07 3.3 7.471e-07 3.3 7.5e-07 3.3 7.501e-07 3.3 7.53e-07 3.3 7.531e-07 3.3 7.56e-07 3.3 7.561e-07 0 7.59e-07 0 7.59e-07 0 7.62e-07 0 7.62e-07 0 7.65e-07 0 7.65e-07 0 7.68e-07 0 7.68e-07 0 7.71e-07 0 7.711e-07 0 7.74e-07 0 7.741e-07 0 7.77e-07 0 7.771e-07 0 7.8e-07 0 7.8e-07 3.3 7.83e-07 3.3 7.83e-07 3.3 7.86e-07 3.3 7.86e-07 3.3 7.89e-07 3.3 7.89e-07 3.3 7.92e-07 3.3 7.921e-07 3.3 7.95e-07 3.3 7.951e-07 3.3 7.98e-07 3.3 7.981e-07 3.3 8.01e-07 3.3 8.011e-07 3.3 8.04e-07 3.3 8.04e-07 0 8.07e-07 0 8.07e-07 0 8.1e-07 0 8.1e-07 0 8.13e-07 0 8.13e-07 0 8.16e-07 0 8.161e-07 0 8.19e-07 0 8.191e-07 0 8.22e-07 0 8.221e-07 0 8.25e-07 0 8.251e-07 0 8.28e-07 0 8.28e-07 3.3 8.31e-07 3.3 8.31e-07 3.3 8.34e-07 3.3 8.34e-07 3.3 8.37e-07 3.3 8.37e-07 3.3 8.4e-07 3.3 8.401e-07 3.3 8.43e-07 3.3 8.431e-07 3.3 8.46e-07 3.3 8.461e-07 3.3 8.49e-07 3.3 8.491e-07 3.3 8.52e-07 3.3 8.52e-07 0 8.55e-07 0 8.55e-07 0 8.58e-07 0 8.58e-07 0 8.61e-07 0 8.61e-07 0 8.64e-07 0 8.641e-07 0 8.67e-07 0 8.671e-07 0 8.7e-07 0 8.701e-07 0 8.73e-07 0 8.73e-07 0 8.76e-07 0 8.76e-07 3.3 8.79e-07 3.3 8.79e-07 3.3 8.82e-07 3.3 8.82e-07 3.3 8.85e-07 3.3 8.851e-07 3.3 8.88e-07 3.3 8.881e-07 3.3 8.91e-07 3.3 8.911e-07 3.3 8.94e-07 3.3 8.941e-07 3.3 8.97e-07 3.3 8.97e-07 3.3 9e-07 3.3 9e-07 0 9.03e-07 0 9.03e-07 0 9.06e-07 0 9.06e-07 0 9.09e-07 0 9.091e-07 0 9.12e-07 0 9.121e-07 0 9.15e-07 0 9.151e-07 0 9.18e-07 0 9.181e-07 0 9.21e-07 0 9.21e-07 0 9.24e-07 0 9.24e-07 3.3 9.27e-07 3.3 9.27e-07 3.3 9.3e-07 3.3 9.3e-07 3.3 9.33e-07 3.3 9.331e-07 3.3 9.36e-07 3.3 9.361e-07 3.3 9.39e-07 3.3 9.391e-07 3.3 9.42e-07 3.3 9.421e-07 3.3 9.45e-07 3.3 9.45e-07 3.3 9.48e-07 3.3 9.48e-07 0 9.51e-07 0 9.51e-07 0 9.54e-07 0 9.54e-07 0 9.57e-07 0 9.57e-07 0 9.6e-07 0 9.6e-07 0 9.63e-07 0 9.63e-07 0 9.66e-07 0 9.66e-07 0 9.69e-07 0 9.69e-07 0 9.72e-07 0 9.72e-07 3.3 9.75e-07 3.3 9.75e-07 3.3 9.78e-07 3.3 9.78e-07 3.3 9.81e-07 3.3 9.81e-07 3.3 9.84e-07 3.3 9.84e-07 3.3 9.87e-07 3.3 9.87e-07 3.3 9.9e-07 3.3 9.9e-07 3.3 9.93e-07 3.3 9.93e-07 3.3 9.96e-07 3.3 9.96e-07 0 9.99e-07 0 9.99e-07 0 1.002e-06 0 1.002e-06 0 1.005e-06 0 1.005e-06 0 1.008e-06 0 1.008e-06 0 1.011e-06 0 1.011e-06 0 1.014e-06 0 1.014e-06 0 1.017e-06 0 1.017e-06 0 1.02e-06 0 1.02e-06 3.3 1.023e-06 3.3 1.023e-06 3.3 1.026e-06 3.3 1.026e-06 3.3 1.029e-06 3.3 1.029e-06 3.3 1.032e-06 3.3 1.032e-06 3.3 1.035e-06 3.3 1.035e-06 3.3 1.038e-06 3.3 1.038e-06 3.3 1.041e-06 3.3 1.041e-06 3.3 1.044e-06 3.3 1.044e-06 0 1.047e-06 0 1.047e-06 0 1.05e-06 0 1.05e-06 0 1.053e-06 0 1.053e-06 0 1.056e-06 0 1.056e-06 0 1.059e-06 0 1.059e-06 0 1.062e-06 0 1.062e-06 0 1.065e-06 0 1.065e-06 0 1.068e-06 0 1.068e-06 3.3 1.071e-06 3.3 1.071e-06 3.3 1.074e-06 3.3 1.074e-06 3.3 1.077e-06 3.3 1.077e-06 3.3 1.08e-06 3.3 1.08e-06 3.3 1.083e-06 3.3 1.083e-06 3.3 1.086e-06 3.3 1.086e-06 3.3 1.089e-06 3.3 1.089e-06 3.3 1.092e-06 3.3 1.092e-06 0 1.095e-06 0 1.095e-06 0 1.098e-06 0 1.098e-06 0 1.101e-06 0 1.101e-06 0 1.104e-06 0 1.104e-06 0 1.107e-06 0 1.107e-06 0 1.11e-06 0 1.11e-06 0 1.113e-06 0 1.113e-06 0 1.116e-06 0 1.116e-06 3.3 1.119e-06 3.3 1.119e-06 3.3 1.122e-06 3.3 1.122e-06 3.3 1.125e-06 3.3 1.125e-06 3.3 1.128e-06 3.3 1.128e-06 3.3 1.131e-06 3.3 1.131e-06 3.3 1.134e-06 3.3 1.134e-06 3.3 1.137e-06 3.3 1.137e-06 3.3 1.14e-06 3.3 1.14e-06 0 1.143e-06 0 1.143e-06 0 1.146e-06 0 1.146e-06 0 1.149e-06 0 1.149e-06 0 1.152e-06 0 1.152e-06 0 1.155e-06 0 1.155e-06 0 1.158e-06 0 1.158e-06 0 1.161e-06 0 1.161e-06 0 1.164e-06 0 1.164e-06 3.3 1.167e-06 3.3 1.167e-06 3.3 1.17e-06 3.3 1.17e-06 3.3 1.173e-06 3.3 1.173e-06 3.3 1.176e-06 3.3 1.176e-06 3.3 1.179e-06 3.3 1.179e-06 3.3 1.182e-06 3.3 1.182e-06 3.3 1.185e-06 3.3 1.185e-06 3.3 1.188e-06 3.3 1.188e-06 0 1.191e-06 0 1.191e-06 0 1.194e-06 0 1.194e-06 0 1.197e-06 0 1.197e-06 0 1.2e-06 0 1.2e-06 0 1.203e-06 0 1.203e-06 0 1.206e-06 0 1.206e-06 0 1.209e-06 0 1.209e-06 0 1.212e-06 0 1.212e-06 3.3 1.215e-06 3.3 1.215e-06 3.3 1.218e-06 3.3 1.218e-06 3.3 1.221e-06 3.3 1.221e-06 3.3 1.224e-06 3.3 1.224e-06 3.3 1.227e-06 3.3 1.227e-06 3.3 1.23e-06 3.3 1.23e-06 3.3 1.233e-06 3.3 1.233e-06 3.3 1.236e-06 3.3 1.236e-06 0 1.239e-06 0 1.239e-06 0 1.242e-06 0 1.242e-06 0 1.245e-06 0 1.245e-06 0 1.248e-06 0 1.248e-06 0 1.251e-06 0 1.251e-06 0 1.254e-06 0 1.254e-06 0 1.257e-06 0 1.257e-06 0 1.26e-06 0 1.26e-06 3.3 1.263e-06 3.3 1.263e-06 3.3 1.266e-06 3.3 1.266e-06 3.3 1.269e-06 3.3 1.269e-06 3.3 1.272e-06 3.3 1.272e-06 3.3 1.275e-06 3.3 1.275e-06 3.3 1.278e-06 3.3 1.278e-06 3.3 1.281e-06 3.3 1.281e-06 3.3 1.284e-06 3.3 1.284e-06 0 1.287e-06 0 1.287e-06 0 1.29e-06 0 1.29e-06 0 1.293e-06 0 1.293e-06 0 1.296e-06 0 1.296e-06 0 1.299e-06 0 1.299e-06 0 1.302e-06 0 1.302e-06 0 1.305e-06 0 1.305e-06 0 1.308e-06 0 1.308e-06 3.3 1.311e-06 3.3 1.311e-06 3.3 1.314e-06 3.3 1.314e-06 3.3 1.317e-06 3.3 1.317e-06 3.3 1.32e-06 3.3 1.32e-06 3.3 1.323e-06 3.3 1.323e-06 3.3 1.326e-06 3.3 1.326e-06 3.3 1.329e-06 3.3 1.329e-06 3.3 1.332e-06 3.3 1.332e-06 0 1.335e-06 0 1.335e-06 0 1.338e-06 0 1.338e-06 0 1.341e-06 0 1.341e-06 0 1.344e-06 0 1.344e-06 0 1.347e-06 0 1.347e-06 0 1.35e-06 0 1.35e-06 0 1.353e-06 0 1.353e-06 0 1.356e-06 0 1.356e-06 3.3 1.359e-06 3.3 1.359e-06 3.3 1.362e-06 3.3 1.362e-06 3.3 1.365e-06 3.3 1.365e-06 3.3 1.368e-06 3.3 1.368e-06 3.3 1.371e-06 3.3 1.371e-06 3.3 1.374e-06 3.3 1.374e-06 3.3 1.377e-06 3.3 1.377e-06 3.3 1.38e-06 3.3 1.38e-06 0 1.383e-06 0 1.383e-06 0 1.386e-06 0 1.386e-06 0 1.389e-06 0 1.389e-06 0 1.392e-06 0 1.392e-06 0 1.395e-06 0 1.395e-06 0 1.398e-06 0 1.398e-06 0 1.401e-06 0 1.401e-06 0 1.404e-06 0 1.404e-06 3.3 1.407e-06 3.3 1.407e-06 3.3 1.41e-06 3.3 1.41e-06 3.3 1.413e-06 3.3 1.413e-06 3.3 1.416e-06 3.3 1.416e-06 3.3 1.419e-06 3.3 1.419e-06 3.3 1.422e-06 3.3 1.422e-06 3.3 1.425e-06 3.3 1.425e-06 3.3 1.428e-06 3.3 1.428e-06 0 1.431e-06 0 1.431e-06 0 1.434e-06 0 1.434e-06 0 1.437e-06 0 1.437e-06 0 1.44e-06 0 1.44e-06 0 1.443e-06 0 1.443e-06 0 1.446e-06 0 1.446e-06 0 1.449e-06 0 1.449e-06 0 1.452e-06 0 1.452e-06 3.3 1.455e-06 3.3 1.455e-06 3.3 1.458e-06 3.3 1.458e-06 3.3 1.461e-06 3.3 1.461e-06 3.3 1.464e-06 3.3 1.464e-06 3.3 1.467e-06 3.3 1.467e-06 3.3 1.47e-06 3.3 1.47e-06 3.3 1.473e-06 3.3 1.473e-06 3.3 1.476e-06 3.3 1.476e-06 0 1.479e-06 0 1.479e-06 0 1.482e-06 0 1.482e-06 0 1.485e-06 0 1.485e-06 0 1.488e-06 0 1.488e-06 0 1.491e-06 0 1.491e-06 0 1.494e-06 0 1.494e-06 0 1.497e-06 0 1.497e-06 0 1.5e-06 0 1.5e-06 3.3 1.503e-06 3.3 1.503e-06 3.3 1.506e-06 3.3 1.506e-06 3.3 1.509e-06 3.3 1.509e-06 3.3 1.512e-06 3.3 1.512e-06 3.3 1.515e-06 3.3 1.515e-06 3.3 1.518e-06 3.3 1.518e-06 3.3 1.521e-06 3.3 1.521e-06 3.3 1.524e-06 3.3 1.524e-06 0 1.527e-06 0 1.527e-06 0 1.53e-06 0 1.53e-06 0 1.533e-06 0 1.533e-06 0)
VA3 A3 0 PWL(0 0 3e-09 0 3.05e-09 0 6e-09 0 6.05e-09 0 9e-09 0 9.05e-09 0 1.2e-08 0 1.205e-08 0 1.5e-08 0 1.505e-08 0 1.8e-08 0 1.805e-08 0 2.1e-08 0 2.105e-08 0 2.4e-08 0 2.405e-08 3.3 2.7e-08 3.3 2.705e-08 3.3 3e-08 3.3 3.005e-08 3.3 3.3e-08 3.3 3.305e-08 3.3 3.6e-08 3.3 3.605e-08 3.3 3.9e-08 3.3 3.905e-08 3.3 4.2e-08 3.3 4.205e-08 3.3 4.5e-08 3.3 4.505e-08 3.3 4.8e-08 3.3 4.805e-08 3.3 5.1e-08 3.3 5.105e-08 3.3 5.4e-08 3.3 5.405e-08 3.3 5.7e-08 3.3 5.705e-08 3.3 6e-08 3.3 6.005e-08 3.3 6.3e-08 3.3 6.305e-08 3.3 6.6e-08 3.3 6.605e-08 3.3 6.9e-08 3.3 6.905e-08 3.3 7.2e-08 3.3 7.205e-08 0 7.5e-08 0 7.505e-08 0 7.8e-08 0 7.805e-08 0 8.1e-08 0 8.105e-08 0 8.4e-08 0 8.405e-08 0 8.7e-08 0 8.705e-08 0 9e-08 0 9.005e-08 0 9.3e-08 0 9.305e-08 0 9.6e-08 0 9.605e-08 0 9.9e-08 0 9.905e-08 0 1.02e-07 0 1.021e-07 0 1.05e-07 0 1.051e-07 0 1.08e-07 0 1.081e-07 0 1.11e-07 0 1.111e-07 0 1.14e-07 0 1.141e-07 0 1.17e-07 0 1.171e-07 0 1.2e-07 0 1.2e-07 3.3 1.23e-07 3.3 1.231e-07 3.3 1.26e-07 3.3 1.26e-07 3.3 1.29e-07 3.3 1.291e-07 3.3 1.32e-07 3.3 1.32e-07 3.3 1.35e-07 3.3 1.351e-07 3.3 1.38e-07 3.3 1.38e-07 3.3 1.41e-07 3.3 1.411e-07 3.3 1.44e-07 3.3 1.44e-07 3.3 1.47e-07 3.3 1.471e-07 3.3 1.5e-07 3.3 1.5e-07 3.3 1.53e-07 3.3 1.531e-07 3.3 1.56e-07 3.3 1.56e-07 3.3 1.59e-07 3.3 1.591e-07 3.3 1.62e-07 3.3 1.62e-07 3.3 1.65e-07 3.3 1.651e-07 3.3 1.68e-07 3.3 1.68e-07 0 1.71e-07 0 1.711e-07 0 1.74e-07 0 1.741e-07 0 1.77e-07 0 1.771e-07 0 1.8e-07 0 1.801e-07 0 1.83e-07 0 1.831e-07 0 1.86e-07 0 1.861e-07 0 1.89e-07 0 1.891e-07 0 1.92e-07 0 1.921e-07 0 1.95e-07 0 1.95e-07 0 1.98e-07 0 1.981e-07 0 2.01e-07 0 2.01e-07 0 2.04e-07 0 2.041e-07 0 2.07e-07 0 2.07e-07 0 2.1e-07 0 2.101e-07 0 2.13e-07 0 2.13e-07 0 2.16e-07 0 2.161e-07 3.3 2.19e-07 3.3 2.19e-07 3.3 2.22e-07 3.3 2.221e-07 3.3 2.25e-07 3.3 2.25e-07 3.3 2.28e-07 3.3 2.281e-07 3.3 2.31e-07 3.3 2.31e-07 3.3 2.34e-07 3.3 2.341e-07 3.3 2.37e-07 3.3 2.37e-07 3.3 2.4e-07 3.3 2.4e-07 3.3 2.43e-07 3.3 2.43e-07 3.3 2.46e-07 3.3 2.461e-07 3.3 2.49e-07 3.3 2.491e-07 3.3 2.52e-07 3.3 2.52e-07 3.3 2.55e-07 3.3 2.55e-07 3.3 2.58e-07 3.3 2.581e-07 3.3 2.61e-07 3.3 2.611e-07 3.3 2.64e-07 3.3 2.64e-07 0 2.67e-07 0 2.67e-07 0 2.7e-07 0 2.701e-07 0 2.73e-07 0 2.731e-07 0 2.76e-07 0 2.76e-07 0 2.79e-07 0 2.791e-07 0 2.82e-07 0 2.821e-07 0 2.85e-07 0 2.851e-07 0 2.88e-07 0 2.88e-07 0 2.91e-07 0 2.911e-07 0 2.94e-07 0 2.941e-07 0 2.97e-07 0 2.97e-07 0 3e-07 0 3e-07 0 3.03e-07 0 3.031e-07 0 3.06e-07 0 3.061e-07 0 3.09e-07 0 3.09e-07 0 3.12e-07 0 3.12e-07 3.3 3.15e-07 3.3 3.151e-07 3.3 3.18e-07 3.3 3.181e-07 3.3 3.21e-07 3.3 3.21e-07 3.3 3.24e-07 3.3 3.24e-07 3.3 3.27e-07 3.3 3.271e-07 3.3 3.3e-07 3.3 3.301e-07 3.3 3.33e-07 3.3 3.33e-07 3.3 3.36e-07 3.3 3.36e-07 3.3 3.39e-07 3.3 3.391e-07 3.3 3.42e-07 3.3 3.421e-07 3.3 3.45e-07 3.3 3.45e-07 3.3 3.48e-07 3.3 3.48e-07 3.3 3.51e-07 3.3 3.511e-07 3.3 3.54e-07 3.3 3.541e-07 3.3 3.57e-07 3.3 3.57e-07 3.3 3.6e-07 3.3 3.6e-07 0 3.63e-07 0 3.631e-07 0 3.66e-07 0 3.661e-07 0 3.69e-07 0 3.69e-07 0 3.72e-07 0 3.72e-07 0 3.75e-07 0 3.751e-07 0 3.78e-07 0 3.781e-07 0 3.81e-07 0 3.81e-07 0 3.84e-07 0 3.841e-07 0 3.87e-07 0 3.871e-07 0 3.9e-07 0 3.9e-07 0 3.93e-07 0 3.93e-07 0 3.96e-07 0 3.961e-07 0 3.99e-07 0 3.991e-07 0 4.02e-07 0 4.02e-07 0 4.05e-07 0 4.05e-07 0 4.08e-07 0 4.081e-07 3.3 4.11e-07 3.3 4.111e-07 3.3 4.14e-07 3.3 4.14e-07 3.3 4.17e-07 3.3 4.17e-07 3.3 4.2e-07 3.3 4.201e-07 3.3 4.23e-07 3.3 4.231e-07 3.3 4.26e-07 3.3 4.26e-07 3.3 4.29e-07 3.3 4.29e-07 3.3 4.32e-07 3.3 4.321e-07 3.3 4.35e-07 3.3 4.351e-07 3.3 4.38e-07 3.3 4.38e-07 3.3 4.41e-07 3.3 4.41e-07 3.3 4.44e-07 3.3 4.441e-07 3.3 4.47e-07 3.3 4.471e-07 3.3 4.5e-07 3.3 4.5e-07 3.3 4.53e-07 3.3 4.53e-07 3.3 4.56e-07 3.3 4.561e-07 0 4.59e-07 0 4.591e-07 0 4.62e-07 0 4.62e-07 0 4.65e-07 0 4.65e-07 0 4.68e-07 0 4.681e-07 0 4.71e-07 0 4.711e-07 0 4.74e-07 0 4.74e-07 0 4.77e-07 0 4.771e-07 0 4.8e-07 0 4.8e-07 0 4.83e-07 0 4.83e-07 0 4.86e-07 0 4.86e-07 0 4.89e-07 0 4.891e-07 0 4.92e-07 0 4.921e-07 0 4.95e-07 0 4.951e-07 0 4.98e-07 0 4.981e-07 0 5.01e-07 0 5.01e-07 0 5.04e-07 0 5.04e-07 3.3 5.07e-07 3.3 5.07e-07 3.3 5.1e-07 3.3 5.1e-07 3.3 5.13e-07 3.3 5.131e-07 3.3 5.16e-07 3.3 5.161e-07 3.3 5.19e-07 3.3 5.191e-07 3.3 5.22e-07 3.3 5.221e-07 3.3 5.25e-07 3.3 5.25e-07 3.3 5.28e-07 3.3 5.28e-07 3.3 5.31e-07 3.3 5.31e-07 3.3 5.34e-07 3.3 5.34e-07 3.3 5.37e-07 3.3 5.371e-07 3.3 5.4e-07 3.3 5.401e-07 3.3 5.43e-07 3.3 5.431e-07 3.3 5.46e-07 3.3 5.461e-07 3.3 5.49e-07 3.3 5.49e-07 3.3 5.52e-07 3.3 5.52e-07 0 5.55e-07 0 5.55e-07 0 5.58e-07 0 5.58e-07 0 5.61e-07 0 5.611e-07 0 5.64e-07 0 5.641e-07 0 5.67e-07 0 5.671e-07 0 5.7e-07 0 5.701e-07 0 5.73e-07 0 5.73e-07 0 5.76e-07 0 5.76e-07 0 5.79e-07 0 5.79e-07 0 5.82e-07 0 5.821e-07 0 5.85e-07 0 5.851e-07 0 5.88e-07 0 5.881e-07 0 5.91e-07 0 5.911e-07 0 5.94e-07 0 5.94e-07 0 5.97e-07 0 5.97e-07 0 6e-07 0 6e-07 3.3 6.03e-07 3.3 6.03e-07 3.3 6.06e-07 3.3 6.061e-07 3.3 6.09e-07 3.3 6.091e-07 3.3 6.12e-07 3.3 6.121e-07 3.3 6.15e-07 3.3 6.151e-07 3.3 6.18e-07 3.3 6.18e-07 3.3 6.21e-07 3.3 6.21e-07 3.3 6.24e-07 3.3 6.24e-07 3.3 6.27e-07 3.3 6.27e-07 3.3 6.3e-07 3.3 6.301e-07 3.3 6.33e-07 3.3 6.331e-07 3.3 6.36e-07 3.3 6.361e-07 3.3 6.39e-07 3.3 6.391e-07 3.3 6.42e-07 3.3 6.42e-07 3.3 6.45e-07 3.3 6.45e-07 3.3 6.48e-07 3.3 6.48e-07 0 6.51e-07 0 6.51e-07 0 6.54e-07 0 6.541e-07 0 6.57e-07 0 6.571e-07 0 6.6e-07 0 6.601e-07 0 6.63e-07 0 6.631e-07 0 6.66e-07 0 6.66e-07 0 6.69e-07 0 6.69e-07 0 6.72e-07 0 6.72e-07 0 6.75e-07 0 6.75e-07 0 6.78e-07 0 6.781e-07 0 6.81e-07 0 6.811e-07 0 6.84e-07 0 6.841e-07 0 6.87e-07 0 6.87e-07 0 6.9e-07 0 6.9e-07 0 6.93e-07 0 6.93e-07 0 6.96e-07 0 6.96e-07 3.3 6.99e-07 3.3 6.991e-07 3.3 7.02e-07 3.3 7.021e-07 3.3 7.05e-07 3.3 7.051e-07 3.3 7.08e-07 3.3 7.081e-07 3.3 7.11e-07 3.3 7.11e-07 3.3 7.14e-07 3.3 7.14e-07 3.3 7.17e-07 3.3 7.17e-07 3.3 7.2e-07 3.3 7.2e-07 3.3 7.23e-07 3.3 7.231e-07 3.3 7.26e-07 3.3 7.261e-07 3.3 7.29e-07 3.3 7.291e-07 3.3 7.32e-07 3.3 7.321e-07 3.3 7.35e-07 3.3 7.35e-07 3.3 7.38e-07 3.3 7.38e-07 3.3 7.41e-07 3.3 7.41e-07 3.3 7.44e-07 3.3 7.44e-07 0 7.47e-07 0 7.471e-07 0 7.5e-07 0 7.501e-07 0 7.53e-07 0 7.531e-07 0 7.56e-07 0 7.561e-07 0 7.59e-07 0 7.59e-07 0 7.62e-07 0 7.62e-07 0 7.65e-07 0 7.65e-07 0 7.68e-07 0 7.68e-07 0 7.71e-07 0 7.711e-07 0 7.74e-07 0 7.741e-07 0 7.77e-07 0 7.771e-07 0 7.8e-07 0 7.8e-07 0 7.83e-07 0 7.83e-07 0 7.86e-07 0 7.86e-07 0 7.89e-07 0 7.89e-07 0 7.92e-07 0 7.921e-07 3.3 7.95e-07 3.3 7.951e-07 3.3 7.98e-07 3.3 7.981e-07 3.3 8.01e-07 3.3 8.011e-07 3.3 8.04e-07 3.3 8.04e-07 3.3 8.07e-07 3.3 8.07e-07 3.3 8.1e-07 3.3 8.1e-07 3.3 8.13e-07 3.3 8.13e-07 3.3 8.16e-07 3.3 8.161e-07 3.3 8.19e-07 3.3 8.191e-07 3.3 8.22e-07 3.3 8.221e-07 3.3 8.25e-07 3.3 8.251e-07 3.3 8.28e-07 3.3 8.28e-07 3.3 8.31e-07 3.3 8.31e-07 3.3 8.34e-07 3.3 8.34e-07 3.3 8.37e-07 3.3 8.37e-07 3.3 8.4e-07 3.3 8.401e-07 0 8.43e-07 0 8.431e-07 0 8.46e-07 0 8.461e-07 0 8.49e-07 0 8.491e-07 0 8.52e-07 0 8.52e-07 0 8.55e-07 0 8.55e-07 0 8.58e-07 0 8.58e-07 0 8.61e-07 0 8.61e-07 0 8.64e-07 0 8.641e-07 0 8.67e-07 0 8.671e-07 0 8.7e-07 0 8.701e-07 0 8.73e-07 0 8.73e-07 0 8.76e-07 0 8.76e-07 0 8.79e-07 0 8.79e-07 0 8.82e-07 0 8.82e-07 0 8.85e-07 0 8.851e-07 0 8.88e-07 0 8.881e-07 3.3 8.91e-07 3.3 8.911e-07 3.3 8.94e-07 3.3 8.941e-07 3.3 8.97e-07 3.3 8.97e-07 3.3 9e-07 3.3 9e-07 3.3 9.03e-07 3.3 9.03e-07 3.3 9.06e-07 3.3 9.06e-07 3.3 9.09e-07 3.3 9.091e-07 3.3 9.12e-07 3.3 9.121e-07 3.3 9.15e-07 3.3 9.151e-07 3.3 9.18e-07 3.3 9.181e-07 3.3 9.21e-07 3.3 9.21e-07 3.3 9.24e-07 3.3 9.24e-07 3.3 9.27e-07 3.3 9.27e-07 3.3 9.3e-07 3.3 9.3e-07 3.3 9.33e-07 3.3 9.331e-07 3.3 9.36e-07 3.3 9.361e-07 0 9.39e-07 0 9.391e-07 0 9.42e-07 0 9.421e-07 0 9.45e-07 0 9.45e-07 0 9.48e-07 0 9.48e-07 0 9.51e-07 0 9.51e-07 0 9.54e-07 0 9.54e-07 0 9.57e-07 0 9.57e-07 0 9.6e-07 0 9.6e-07 0 9.63e-07 0 9.63e-07 0 9.66e-07 0 9.66e-07 0 9.69e-07 0 9.69e-07 0 9.72e-07 0 9.72e-07 0 9.75e-07 0 9.75e-07 0 9.78e-07 0 9.78e-07 0 9.81e-07 0 9.81e-07 0 9.84e-07 0 9.84e-07 3.3 9.87e-07 3.3 9.87e-07 3.3 9.9e-07 3.3 9.9e-07 3.3 9.93e-07 3.3 9.93e-07 3.3 9.96e-07 3.3 9.96e-07 3.3 9.99e-07 3.3 9.99e-07 3.3 1.002e-06 3.3 1.002e-06 3.3 1.005e-06 3.3 1.005e-06 3.3 1.008e-06 3.3 1.008e-06 3.3 1.011e-06 3.3 1.011e-06 3.3 1.014e-06 3.3 1.014e-06 3.3 1.017e-06 3.3 1.017e-06 3.3 1.02e-06 3.3 1.02e-06 3.3 1.023e-06 3.3 1.023e-06 3.3 1.026e-06 3.3 1.026e-06 3.3 1.029e-06 3.3 1.029e-06 3.3 1.032e-06 3.3 1.032e-06 0 1.035e-06 0 1.035e-06 0 1.038e-06 0 1.038e-06 0 1.041e-06 0 1.041e-06 0 1.044e-06 0 1.044e-06 0 1.047e-06 0 1.047e-06 0 1.05e-06 0 1.05e-06 0 1.053e-06 0 1.053e-06 0 1.056e-06 0 1.056e-06 0 1.059e-06 0 1.059e-06 0 1.062e-06 0 1.062e-06 0 1.065e-06 0 1.065e-06 0 1.068e-06 0 1.068e-06 0 1.071e-06 0 1.071e-06 0 1.074e-06 0 1.074e-06 0 1.077e-06 0 1.077e-06 0 1.08e-06 0 1.08e-06 3.3 1.083e-06 3.3 1.083e-06 3.3 1.086e-06 3.3 1.086e-06 3.3 1.089e-06 3.3 1.089e-06 3.3 1.092e-06 3.3 1.092e-06 3.3 1.095e-06 3.3 1.095e-06 3.3 1.098e-06 3.3 1.098e-06 3.3 1.101e-06 3.3 1.101e-06 3.3 1.104e-06 3.3 1.104e-06 3.3 1.107e-06 3.3 1.107e-06 3.3 1.11e-06 3.3 1.11e-06 3.3 1.113e-06 3.3 1.113e-06 3.3 1.116e-06 3.3 1.116e-06 3.3 1.119e-06 3.3 1.119e-06 3.3 1.122e-06 3.3 1.122e-06 3.3 1.125e-06 3.3 1.125e-06 3.3 1.128e-06 3.3 1.128e-06 0 1.131e-06 0 1.131e-06 0 1.134e-06 0 1.134e-06 0 1.137e-06 0 1.137e-06 0 1.14e-06 0 1.14e-06 0 1.143e-06 0 1.143e-06 0 1.146e-06 0 1.146e-06 0 1.149e-06 0 1.149e-06 0 1.152e-06 0 1.152e-06 0 1.155e-06 0 1.155e-06 0 1.158e-06 0 1.158e-06 0 1.161e-06 0 1.161e-06 0 1.164e-06 0 1.164e-06 0 1.167e-06 0 1.167e-06 0 1.17e-06 0 1.17e-06 0 1.173e-06 0 1.173e-06 0 1.176e-06 0 1.176e-06 3.3 1.179e-06 3.3 1.179e-06 3.3 1.182e-06 3.3 1.182e-06 3.3 1.185e-06 3.3 1.185e-06 3.3 1.188e-06 3.3 1.188e-06 3.3 1.191e-06 3.3 1.191e-06 3.3 1.194e-06 3.3 1.194e-06 3.3 1.197e-06 3.3 1.197e-06 3.3 1.2e-06 3.3 1.2e-06 3.3 1.203e-06 3.3 1.203e-06 3.3 1.206e-06 3.3 1.206e-06 3.3 1.209e-06 3.3 1.209e-06 3.3 1.212e-06 3.3 1.212e-06 3.3 1.215e-06 3.3 1.215e-06 3.3 1.218e-06 3.3 1.218e-06 3.3 1.221e-06 3.3 1.221e-06 3.3 1.224e-06 3.3 1.224e-06 0 1.227e-06 0 1.227e-06 0 1.23e-06 0 1.23e-06 0 1.233e-06 0 1.233e-06 0 1.236e-06 0 1.236e-06 0 1.239e-06 0 1.239e-06 0 1.242e-06 0 1.242e-06 0 1.245e-06 0 1.245e-06 0 1.248e-06 0 1.248e-06 0 1.251e-06 0 1.251e-06 0 1.254e-06 0 1.254e-06 0 1.257e-06 0 1.257e-06 0 1.26e-06 0 1.26e-06 0 1.263e-06 0 1.263e-06 0 1.266e-06 0 1.266e-06 0 1.269e-06 0 1.269e-06 0 1.272e-06 0 1.272e-06 3.3 1.275e-06 3.3 1.275e-06 3.3 1.278e-06 3.3 1.278e-06 3.3 1.281e-06 3.3 1.281e-06 3.3 1.284e-06 3.3 1.284e-06 3.3 1.287e-06 3.3 1.287e-06 3.3 1.29e-06 3.3 1.29e-06 3.3 1.293e-06 3.3 1.293e-06 3.3 1.296e-06 3.3 1.296e-06 3.3 1.299e-06 3.3 1.299e-06 3.3 1.302e-06 3.3 1.302e-06 3.3 1.305e-06 3.3 1.305e-06 3.3 1.308e-06 3.3 1.308e-06 3.3 1.311e-06 3.3 1.311e-06 3.3 1.314e-06 3.3 1.314e-06 3.3 1.317e-06 3.3 1.317e-06 3.3 1.32e-06 3.3 1.32e-06 0 1.323e-06 0 1.323e-06 0 1.326e-06 0 1.326e-06 0 1.329e-06 0 1.329e-06 0 1.332e-06 0 1.332e-06 0 1.335e-06 0 1.335e-06 0 1.338e-06 0 1.338e-06 0 1.341e-06 0 1.341e-06 0 1.344e-06 0 1.344e-06 0 1.347e-06 0 1.347e-06 0 1.35e-06 0 1.35e-06 0 1.353e-06 0 1.353e-06 0 1.356e-06 0 1.356e-06 0 1.359e-06 0 1.359e-06 0 1.362e-06 0 1.362e-06 0 1.365e-06 0 1.365e-06 0 1.368e-06 0 1.368e-06 3.3 1.371e-06 3.3 1.371e-06 3.3 1.374e-06 3.3 1.374e-06 3.3 1.377e-06 3.3 1.377e-06 3.3 1.38e-06 3.3 1.38e-06 3.3 1.383e-06 3.3 1.383e-06 3.3 1.386e-06 3.3 1.386e-06 3.3 1.389e-06 3.3 1.389e-06 3.3 1.392e-06 3.3 1.392e-06 3.3 1.395e-06 3.3 1.395e-06 3.3 1.398e-06 3.3 1.398e-06 3.3 1.401e-06 3.3 1.401e-06 3.3 1.404e-06 3.3 1.404e-06 3.3 1.407e-06 3.3 1.407e-06 3.3 1.41e-06 3.3 1.41e-06 3.3 1.413e-06 3.3 1.413e-06 3.3 1.416e-06 3.3 1.416e-06 0 1.419e-06 0 1.419e-06 0 1.422e-06 0 1.422e-06 0 1.425e-06 0 1.425e-06 0 1.428e-06 0 1.428e-06 0 1.431e-06 0 1.431e-06 0 1.434e-06 0 1.434e-06 0 1.437e-06 0 1.437e-06 0 1.44e-06 0 1.44e-06 0 1.443e-06 0 1.443e-06 0 1.446e-06 0 1.446e-06 0 1.449e-06 0 1.449e-06 0 1.452e-06 0 1.452e-06 0 1.455e-06 0 1.455e-06 0 1.458e-06 0 1.458e-06 0 1.461e-06 0 1.461e-06 0 1.464e-06 0 1.464e-06 3.3 1.467e-06 3.3 1.467e-06 3.3 1.47e-06 3.3 1.47e-06 3.3 1.473e-06 3.3 1.473e-06 3.3 1.476e-06 3.3 1.476e-06 3.3 1.479e-06 3.3 1.479e-06 3.3 1.482e-06 3.3 1.482e-06 3.3 1.485e-06 3.3 1.485e-06 3.3 1.488e-06 3.3 1.488e-06 3.3 1.491e-06 3.3 1.491e-06 3.3 1.494e-06 3.3 1.494e-06 3.3 1.497e-06 3.3 1.497e-06 3.3 1.5e-06 3.3 1.5e-06 3.3 1.503e-06 3.3 1.503e-06 3.3 1.506e-06 3.3 1.506e-06 3.3 1.509e-06 3.3 1.509e-06 3.3 1.512e-06 3.3 1.512e-06 0 1.515e-06 0 1.515e-06 0 1.518e-06 0 1.518e-06 0 1.521e-06 0 1.521e-06 0 1.524e-06 0 1.524e-06 0 1.527e-06 0 1.527e-06 0 1.53e-06 0 1.53e-06 0 1.533e-06 0 1.533e-06 0)
VB0 B0 0 PWL(0 0 3e-09 0 3.05e-09 0 6e-09 0 6.05e-09 0 9e-09 0 9.05e-09 0 1.2e-08 0 1.205e-08 0 1.5e-08 0 1.505e-08 0 1.8e-08 0 1.805e-08 0 2.1e-08 0 2.105e-08 0 2.4e-08 0 2.405e-08 0 2.7e-08 0 2.705e-08 0 3e-08 0 3.005e-08 0 3.3e-08 0 3.305e-08 0 3.6e-08 0 3.605e-08 0 3.9e-08 0 3.905e-08 0 4.2e-08 0 4.205e-08 0 4.5e-08 0 4.505e-08 0 4.8e-08 0 4.805e-08 3.3 5.1e-08 3.3 5.105e-08 3.3 5.4e-08 3.3 5.405e-08 3.3 5.7e-08 3.3 5.705e-08 3.3 6e-08 3.3 6.005e-08 3.3 6.3e-08 3.3 6.305e-08 3.3 6.6e-08 3.3 6.605e-08 3.3 6.9e-08 3.3 6.905e-08 3.3 7.2e-08 3.3 7.205e-08 3.3 7.5e-08 3.3 7.505e-08 3.3 7.8e-08 3.3 7.805e-08 3.3 8.1e-08 3.3 8.105e-08 3.3 8.4e-08 3.3 8.405e-08 3.3 8.7e-08 3.3 8.705e-08 3.3 9e-08 3.3 9.005e-08 3.3 9.3e-08 3.3 9.305e-08 3.3 9.6e-08 3.3 9.605e-08 3.3 9.9e-08 3.3 9.905e-08 3.3 1.02e-07 3.3 1.021e-07 3.3 1.05e-07 3.3 1.051e-07 3.3 1.08e-07 3.3 1.081e-07 3.3 1.11e-07 3.3 1.111e-07 3.3 1.14e-07 3.3 1.141e-07 3.3 1.17e-07 3.3 1.171e-07 3.3 1.2e-07 3.3 1.2e-07 3.3 1.23e-07 3.3 1.231e-07 3.3 1.26e-07 3.3 1.26e-07 3.3 1.29e-07 3.3 1.291e-07 3.3 1.32e-07 3.3 1.32e-07 3.3 1.35e-07 3.3 1.351e-07 3.3 1.38e-07 3.3 1.38e-07 3.3 1.41e-07 3.3 1.411e-07 3.3 1.44e-07 3.3 1.44e-07 0 1.47e-07 0 1.471e-07 0 1.5e-07 0 1.5e-07 0 1.53e-07 0 1.531e-07 0 1.56e-07 0 1.56e-07 0 1.59e-07 0 1.591e-07 0 1.62e-07 0 1.62e-07 0 1.65e-07 0 1.651e-07 0 1.68e-07 0 1.68e-07 0 1.71e-07 0 1.711e-07 0 1.74e-07 0 1.741e-07 0 1.77e-07 0 1.771e-07 0 1.8e-07 0 1.801e-07 0 1.83e-07 0 1.831e-07 0 1.86e-07 0 1.861e-07 0 1.89e-07 0 1.891e-07 0 1.92e-07 0 1.921e-07 0 1.95e-07 0 1.95e-07 0 1.98e-07 0 1.981e-07 0 2.01e-07 0 2.01e-07 0 2.04e-07 0 2.041e-07 0 2.07e-07 0 2.07e-07 0 2.1e-07 0 2.101e-07 0 2.13e-07 0 2.13e-07 0 2.16e-07 0 2.161e-07 0 2.19e-07 0 2.19e-07 0 2.22e-07 0 2.221e-07 0 2.25e-07 0 2.25e-07 0 2.28e-07 0 2.281e-07 0 2.31e-07 0 2.31e-07 0 2.34e-07 0 2.341e-07 0 2.37e-07 0 2.37e-07 0 2.4e-07 0 2.4e-07 3.3 2.43e-07 3.3 2.43e-07 3.3 2.46e-07 3.3 2.461e-07 3.3 2.49e-07 3.3 2.491e-07 3.3 2.52e-07 3.3 2.52e-07 3.3 2.55e-07 3.3 2.55e-07 3.3 2.58e-07 3.3 2.581e-07 3.3 2.61e-07 3.3 2.611e-07 3.3 2.64e-07 3.3 2.64e-07 3.3 2.67e-07 3.3 2.67e-07 3.3 2.7e-07 3.3 2.701e-07 3.3 2.73e-07 3.3 2.731e-07 3.3 2.76e-07 3.3 2.76e-07 3.3 2.79e-07 3.3 2.791e-07 3.3 2.82e-07 3.3 2.821e-07 3.3 2.85e-07 3.3 2.851e-07 3.3 2.88e-07 3.3 2.88e-07 3.3 2.91e-07 3.3 2.911e-07 3.3 2.94e-07 3.3 2.941e-07 3.3 2.97e-07 3.3 2.97e-07 3.3 3e-07 3.3 3e-07 3.3 3.03e-07 3.3 3.031e-07 3.3 3.06e-07 3.3 3.061e-07 3.3 3.09e-07 3.3 3.09e-07 3.3 3.12e-07 3.3 3.12e-07 3.3 3.15e-07 3.3 3.151e-07 3.3 3.18e-07 3.3 3.181e-07 3.3 3.21e-07 3.3 3.21e-07 3.3 3.24e-07 3.3 3.24e-07 3.3 3.27e-07 3.3 3.271e-07 3.3 3.3e-07 3.3 3.301e-07 3.3 3.33e-07 3.3 3.33e-07 3.3 3.36e-07 3.3 3.36e-07 0 3.39e-07 0 3.391e-07 0 3.42e-07 0 3.421e-07 0 3.45e-07 0 3.45e-07 0 3.48e-07 0 3.48e-07 0 3.51e-07 0 3.511e-07 0 3.54e-07 0 3.541e-07 0 3.57e-07 0 3.57e-07 0 3.6e-07 0 3.6e-07 0 3.63e-07 0 3.631e-07 0 3.66e-07 0 3.661e-07 0 3.69e-07 0 3.69e-07 0 3.72e-07 0 3.72e-07 0 3.75e-07 0 3.751e-07 0 3.78e-07 0 3.781e-07 0 3.81e-07 0 3.81e-07 0 3.84e-07 0 3.841e-07 0 3.87e-07 0 3.871e-07 0 3.9e-07 0 3.9e-07 0 3.93e-07 0 3.93e-07 0 3.96e-07 0 3.961e-07 0 3.99e-07 0 3.991e-07 0 4.02e-07 0 4.02e-07 0 4.05e-07 0 4.05e-07 0 4.08e-07 0 4.081e-07 0 4.11e-07 0 4.111e-07 0 4.14e-07 0 4.14e-07 0 4.17e-07 0 4.17e-07 0 4.2e-07 0 4.201e-07 0 4.23e-07 0 4.231e-07 0 4.26e-07 0 4.26e-07 0 4.29e-07 0 4.29e-07 0 4.32e-07 0 4.321e-07 3.3 4.35e-07 3.3 4.351e-07 3.3 4.38e-07 3.3 4.38e-07 3.3 4.41e-07 3.3 4.41e-07 3.3 4.44e-07 3.3 4.441e-07 3.3 4.47e-07 3.3 4.471e-07 3.3 4.5e-07 3.3 4.5e-07 3.3 4.53e-07 3.3 4.53e-07 3.3 4.56e-07 3.3 4.561e-07 3.3 4.59e-07 3.3 4.591e-07 3.3 4.62e-07 3.3 4.62e-07 3.3 4.65e-07 3.3 4.65e-07 3.3 4.68e-07 3.3 4.681e-07 3.3 4.71e-07 3.3 4.711e-07 3.3 4.74e-07 3.3 4.74e-07 3.3 4.77e-07 3.3 4.771e-07 3.3 4.8e-07 3.3 4.8e-07 3.3 4.83e-07 3.3 4.83e-07 3.3 4.86e-07 3.3 4.86e-07 3.3 4.89e-07 3.3 4.891e-07 3.3 4.92e-07 3.3 4.921e-07 3.3 4.95e-07 3.3 4.951e-07 3.3 4.98e-07 3.3 4.981e-07 3.3 5.01e-07 3.3 5.01e-07 3.3 5.04e-07 3.3 5.04e-07 3.3 5.07e-07 3.3 5.07e-07 3.3 5.1e-07 3.3 5.1e-07 3.3 5.13e-07 3.3 5.131e-07 3.3 5.16e-07 3.3 5.161e-07 3.3 5.19e-07 3.3 5.191e-07 3.3 5.22e-07 3.3 5.221e-07 3.3 5.25e-07 3.3 5.25e-07 3.3 5.28e-07 3.3 5.28e-07 0 5.31e-07 0 5.31e-07 0 5.34e-07 0 5.34e-07 0 5.37e-07 0 5.371e-07 0 5.4e-07 0 5.401e-07 0 5.43e-07 0 5.431e-07 0 5.46e-07 0 5.461e-07 0 5.49e-07 0 5.49e-07 0 5.52e-07 0 5.52e-07 0 5.55e-07 0 5.55e-07 0 5.58e-07 0 5.58e-07 0 5.61e-07 0 5.611e-07 0 5.64e-07 0 5.641e-07 0 5.67e-07 0 5.671e-07 0 5.7e-07 0 5.701e-07 0 5.73e-07 0 5.73e-07 0 5.76e-07 0 5.76e-07 0 5.79e-07 0 5.79e-07 0 5.82e-07 0 5.821e-07 0 5.85e-07 0 5.851e-07 0 5.88e-07 0 5.881e-07 0 5.91e-07 0 5.911e-07 0 5.94e-07 0 5.94e-07 0 5.97e-07 0 5.97e-07 0 6e-07 0 6e-07 0 6.03e-07 0 6.03e-07 0 6.06e-07 0 6.061e-07 0 6.09e-07 0 6.091e-07 0 6.12e-07 0 6.121e-07 0 6.15e-07 0 6.151e-07 0 6.18e-07 0 6.18e-07 0 6.21e-07 0 6.21e-07 0 6.24e-07 0 6.24e-07 3.3 6.27e-07 3.3 6.27e-07 3.3 6.3e-07 3.3 6.301e-07 3.3 6.33e-07 3.3 6.331e-07 3.3 6.36e-07 3.3 6.361e-07 3.3 6.39e-07 3.3 6.391e-07 3.3 6.42e-07 3.3 6.42e-07 3.3 6.45e-07 3.3 6.45e-07 3.3 6.48e-07 3.3 6.48e-07 3.3 6.51e-07 3.3 6.51e-07 3.3 6.54e-07 3.3 6.541e-07 3.3 6.57e-07 3.3 6.571e-07 3.3 6.6e-07 3.3 6.601e-07 3.3 6.63e-07 3.3 6.631e-07 3.3 6.66e-07 3.3 6.66e-07 3.3 6.69e-07 3.3 6.69e-07 3.3 6.72e-07 3.3 6.72e-07 3.3 6.75e-07 3.3 6.75e-07 3.3 6.78e-07 3.3 6.781e-07 3.3 6.81e-07 3.3 6.811e-07 3.3 6.84e-07 3.3 6.841e-07 3.3 6.87e-07 3.3 6.87e-07 3.3 6.9e-07 3.3 6.9e-07 3.3 6.93e-07 3.3 6.93e-07 3.3 6.96e-07 3.3 6.96e-07 3.3 6.99e-07 3.3 6.991e-07 3.3 7.02e-07 3.3 7.021e-07 3.3 7.05e-07 3.3 7.051e-07 3.3 7.08e-07 3.3 7.081e-07 3.3 7.11e-07 3.3 7.11e-07 3.3 7.14e-07 3.3 7.14e-07 3.3 7.17e-07 3.3 7.17e-07 3.3 7.2e-07 3.3 7.2e-07 0 7.23e-07 0 7.231e-07 0 7.26e-07 0 7.261e-07 0 7.29e-07 0 7.291e-07 0 7.32e-07 0 7.321e-07 0 7.35e-07 0 7.35e-07 0 7.38e-07 0 7.38e-07 0 7.41e-07 0 7.41e-07 0 7.44e-07 0 7.44e-07 0 7.47e-07 0 7.471e-07 0 7.5e-07 0 7.501e-07 0 7.53e-07 0 7.531e-07 0 7.56e-07 0 7.561e-07 0 7.59e-07 0 7.59e-07 0 7.62e-07 0 7.62e-07 0 7.65e-07 0 7.65e-07 0 7.68e-07 0 7.68e-07 0 7.71e-07 0 7.711e-07 0 7.74e-07 0 7.741e-07 0 7.77e-07 0 7.771e-07 0 7.8e-07 0 7.8e-07 0 7.83e-07 0 7.83e-07 0 7.86e-07 0 7.86e-07 0 7.89e-07 0 7.89e-07 0 7.92e-07 0 7.921e-07 0 7.95e-07 0 7.951e-07 0 7.98e-07 0 7.981e-07 0 8.01e-07 0 8.011e-07 0 8.04e-07 0 8.04e-07 0 8.07e-07 0 8.07e-07 0 8.1e-07 0 8.1e-07 0 8.13e-07 0 8.13e-07 0 8.16e-07 0 8.161e-07 3.3 8.19e-07 3.3 8.191e-07 3.3 8.22e-07 3.3 8.221e-07 3.3 8.25e-07 3.3 8.251e-07 3.3 8.28e-07 3.3 8.28e-07 3.3 8.31e-07 3.3 8.31e-07 3.3 8.34e-07 3.3 8.34e-07 3.3 8.37e-07 3.3 8.37e-07 3.3 8.4e-07 3.3 8.401e-07 3.3 8.43e-07 3.3 8.431e-07 3.3 8.46e-07 3.3 8.461e-07 3.3 8.49e-07 3.3 8.491e-07 3.3 8.52e-07 3.3 8.52e-07 3.3 8.55e-07 3.3 8.55e-07 3.3 8.58e-07 3.3 8.58e-07 3.3 8.61e-07 3.3 8.61e-07 3.3 8.64e-07 3.3 8.641e-07 3.3 8.67e-07 3.3 8.671e-07 3.3 8.7e-07 3.3 8.701e-07 3.3 8.73e-07 3.3 8.73e-07 3.3 8.76e-07 3.3 8.76e-07 3.3 8.79e-07 3.3 8.79e-07 3.3 8.82e-07 3.3 8.82e-07 3.3 8.85e-07 3.3 8.851e-07 3.3 8.88e-07 3.3 8.881e-07 3.3 8.91e-07 3.3 8.911e-07 3.3 8.94e-07 3.3 8.941e-07 3.3 8.97e-07 3.3 8.97e-07 3.3 9e-07 3.3 9e-07 3.3 9.03e-07 3.3 9.03e-07 3.3 9.06e-07 3.3 9.06e-07 3.3 9.09e-07 3.3 9.091e-07 3.3 9.12e-07 3.3 9.121e-07 0 9.15e-07 0 9.151e-07 0 9.18e-07 0 9.181e-07 0 9.21e-07 0 9.21e-07 0 9.24e-07 0 9.24e-07 0 9.27e-07 0 9.27e-07 0 9.3e-07 0 9.3e-07 0 9.33e-07 0 9.331e-07 0 9.36e-07 0 9.361e-07 0 9.39e-07 0 9.391e-07 0 9.42e-07 0 9.421e-07 0 9.45e-07 0 9.45e-07 0 9.48e-07 0 9.48e-07 0 9.51e-07 0 9.51e-07 0 9.54e-07 0 9.54e-07 0 9.57e-07 0 9.57e-07 0 9.6e-07 0 9.6e-07 0 9.63e-07 0 9.63e-07 0 9.66e-07 0 9.66e-07 0 9.69e-07 0 9.69e-07 0 9.72e-07 0 9.72e-07 0 9.75e-07 0 9.75e-07 0 9.78e-07 0 9.78e-07 0 9.81e-07 0 9.81e-07 0 9.84e-07 0 9.84e-07 0 9.87e-07 0 9.87e-07 0 9.9e-07 0 9.9e-07 0 9.93e-07 0 9.93e-07 0 9.96e-07 0 9.96e-07 0 9.99e-07 0 9.99e-07 0 1.002e-06 0 1.002e-06 0 1.005e-06 0 1.005e-06 0 1.008e-06 0 1.008e-06 3.3 1.011e-06 3.3 1.011e-06 3.3 1.014e-06 3.3 1.014e-06 3.3 1.017e-06 3.3 1.017e-06 3.3 1.02e-06 3.3 1.02e-06 3.3 1.023e-06 3.3 1.023e-06 3.3 1.026e-06 3.3 1.026e-06 3.3 1.029e-06 3.3 1.029e-06 3.3 1.032e-06 3.3 1.032e-06 3.3 1.035e-06 3.3 1.035e-06 3.3 1.038e-06 3.3 1.038e-06 3.3 1.041e-06 3.3 1.041e-06 3.3 1.044e-06 3.3 1.044e-06 3.3 1.047e-06 3.3 1.047e-06 3.3 1.05e-06 3.3 1.05e-06 3.3 1.053e-06 3.3 1.053e-06 3.3 1.056e-06 3.3 1.056e-06 3.3 1.059e-06 3.3 1.059e-06 3.3 1.062e-06 3.3 1.062e-06 3.3 1.065e-06 3.3 1.065e-06 3.3 1.068e-06 3.3 1.068e-06 3.3 1.071e-06 3.3 1.071e-06 3.3 1.074e-06 3.3 1.074e-06 3.3 1.077e-06 3.3 1.077e-06 3.3 1.08e-06 3.3 1.08e-06 3.3 1.083e-06 3.3 1.083e-06 3.3 1.086e-06 3.3 1.086e-06 3.3 1.089e-06 3.3 1.089e-06 3.3 1.092e-06 3.3 1.092e-06 3.3 1.095e-06 3.3 1.095e-06 3.3 1.098e-06 3.3 1.098e-06 3.3 1.101e-06 3.3 1.101e-06 3.3 1.104e-06 3.3 1.104e-06 0 1.107e-06 0 1.107e-06 0 1.11e-06 0 1.11e-06 0 1.113e-06 0 1.113e-06 0 1.116e-06 0 1.116e-06 0 1.119e-06 0 1.119e-06 0 1.122e-06 0 1.122e-06 0 1.125e-06 0 1.125e-06 0 1.128e-06 0 1.128e-06 0 1.131e-06 0 1.131e-06 0 1.134e-06 0 1.134e-06 0 1.137e-06 0 1.137e-06 0 1.14e-06 0 1.14e-06 0 1.143e-06 0 1.143e-06 0 1.146e-06 0 1.146e-06 0 1.149e-06 0 1.149e-06 0 1.152e-06 0 1.152e-06 0 1.155e-06 0 1.155e-06 0 1.158e-06 0 1.158e-06 0 1.161e-06 0 1.161e-06 0 1.164e-06 0 1.164e-06 0 1.167e-06 0 1.167e-06 0 1.17e-06 0 1.17e-06 0 1.173e-06 0 1.173e-06 0 1.176e-06 0 1.176e-06 0 1.179e-06 0 1.179e-06 0 1.182e-06 0 1.182e-06 0 1.185e-06 0 1.185e-06 0 1.188e-06 0 1.188e-06 0 1.191e-06 0 1.191e-06 0 1.194e-06 0 1.194e-06 0 1.197e-06 0 1.197e-06 0 1.2e-06 0 1.2e-06 3.3 1.203e-06 3.3 1.203e-06 3.3 1.206e-06 3.3 1.206e-06 3.3 1.209e-06 3.3 1.209e-06 3.3 1.212e-06 3.3 1.212e-06 3.3 1.215e-06 3.3 1.215e-06 3.3 1.218e-06 3.3 1.218e-06 3.3 1.221e-06 3.3 1.221e-06 3.3 1.224e-06 3.3 1.224e-06 3.3 1.227e-06 3.3 1.227e-06 3.3 1.23e-06 3.3 1.23e-06 3.3 1.233e-06 3.3 1.233e-06 3.3 1.236e-06 3.3 1.236e-06 3.3 1.239e-06 3.3 1.239e-06 3.3 1.242e-06 3.3 1.242e-06 3.3 1.245e-06 3.3 1.245e-06 3.3 1.248e-06 3.3 1.248e-06 3.3 1.251e-06 3.3 1.251e-06 3.3 1.254e-06 3.3 1.254e-06 3.3 1.257e-06 3.3 1.257e-06 3.3 1.26e-06 3.3 1.26e-06 3.3 1.263e-06 3.3 1.263e-06 3.3 1.266e-06 3.3 1.266e-06 3.3 1.269e-06 3.3 1.269e-06 3.3 1.272e-06 3.3 1.272e-06 3.3 1.275e-06 3.3 1.275e-06 3.3 1.278e-06 3.3 1.278e-06 3.3 1.281e-06 3.3 1.281e-06 3.3 1.284e-06 3.3 1.284e-06 3.3 1.287e-06 3.3 1.287e-06 3.3 1.29e-06 3.3 1.29e-06 3.3 1.293e-06 3.3 1.293e-06 3.3 1.296e-06 3.3 1.296e-06 0 1.299e-06 0 1.299e-06 0 1.302e-06 0 1.302e-06 0 1.305e-06 0 1.305e-06 0 1.308e-06 0 1.308e-06 0 1.311e-06 0 1.311e-06 0 1.314e-06 0 1.314e-06 0 1.317e-06 0 1.317e-06 0 1.32e-06 0 1.32e-06 0 1.323e-06 0 1.323e-06 0 1.326e-06 0 1.326e-06 0 1.329e-06 0 1.329e-06 0 1.332e-06 0 1.332e-06 0 1.335e-06 0 1.335e-06 0 1.338e-06 0 1.338e-06 0 1.341e-06 0 1.341e-06 0 1.344e-06 0 1.344e-06 0 1.347e-06 0 1.347e-06 0 1.35e-06 0 1.35e-06 0 1.353e-06 0 1.353e-06 0 1.356e-06 0 1.356e-06 0 1.359e-06 0 1.359e-06 0 1.362e-06 0 1.362e-06 0 1.365e-06 0 1.365e-06 0 1.368e-06 0 1.368e-06 0 1.371e-06 0 1.371e-06 0 1.374e-06 0 1.374e-06 0 1.377e-06 0 1.377e-06 0 1.38e-06 0 1.38e-06 0 1.383e-06 0 1.383e-06 0 1.386e-06 0 1.386e-06 0 1.389e-06 0 1.389e-06 0 1.392e-06 0 1.392e-06 3.3 1.395e-06 3.3 1.395e-06 3.3 1.398e-06 3.3 1.398e-06 3.3 1.401e-06 3.3 1.401e-06 3.3 1.404e-06 3.3 1.404e-06 3.3 1.407e-06 3.3 1.407e-06 3.3 1.41e-06 3.3 1.41e-06 3.3 1.413e-06 3.3 1.413e-06 3.3 1.416e-06 3.3 1.416e-06 3.3 1.419e-06 3.3 1.419e-06 3.3 1.422e-06 3.3 1.422e-06 3.3 1.425e-06 3.3 1.425e-06 3.3 1.428e-06 3.3 1.428e-06 3.3 1.431e-06 3.3 1.431e-06 3.3 1.434e-06 3.3 1.434e-06 3.3 1.437e-06 3.3 1.437e-06 3.3 1.44e-06 3.3 1.44e-06 3.3 1.443e-06 3.3 1.443e-06 3.3 1.446e-06 3.3 1.446e-06 3.3 1.449e-06 3.3 1.449e-06 3.3 1.452e-06 3.3 1.452e-06 3.3 1.455e-06 3.3 1.455e-06 3.3 1.458e-06 3.3 1.458e-06 3.3 1.461e-06 3.3 1.461e-06 3.3 1.464e-06 3.3 1.464e-06 3.3 1.467e-06 3.3 1.467e-06 3.3 1.47e-06 3.3 1.47e-06 3.3 1.473e-06 3.3 1.473e-06 3.3 1.476e-06 3.3 1.476e-06 3.3 1.479e-06 3.3 1.479e-06 3.3 1.482e-06 3.3 1.482e-06 3.3 1.485e-06 3.3 1.485e-06 3.3 1.488e-06 3.3 1.488e-06 0 1.491e-06 0 1.491e-06 0 1.494e-06 0 1.494e-06 0 1.497e-06 0 1.497e-06 0 1.5e-06 0 1.5e-06 0 1.503e-06 0 1.503e-06 0 1.506e-06 0 1.506e-06 0 1.509e-06 0 1.509e-06 0 1.512e-06 0 1.512e-06 0 1.515e-06 0 1.515e-06 0 1.518e-06 0 1.518e-06 0 1.521e-06 0 1.521e-06 0 1.524e-06 0 1.524e-06 0 1.527e-06 0 1.527e-06 0 1.53e-06 0 1.53e-06 0 1.533e-06 0 1.533e-06 0)
VB1 B1 0 PWL(0 0 3e-09 0 3.05e-09 0 6e-09 0 6.05e-09 0 9e-09 0 9.05e-09 0 1.2e-08 0 1.205e-08 0 1.5e-08 0 1.505e-08 0 1.8e-08 0 1.805e-08 0 2.1e-08 0 2.105e-08 0 2.4e-08 0 2.405e-08 0 2.7e-08 0 2.705e-08 0 3e-08 0 3.005e-08 0 3.3e-08 0 3.305e-08 0 3.6e-08 0 3.605e-08 0 3.9e-08 0 3.905e-08 0 4.2e-08 0 4.205e-08 0 4.5e-08 0 4.505e-08 0 4.8e-08 0 4.805e-08 0 5.1e-08 0 5.105e-08 0 5.4e-08 0 5.405e-08 0 5.7e-08 0 5.705e-08 0 6e-08 0 6.005e-08 0 6.3e-08 0 6.305e-08 0 6.6e-08 0 6.605e-08 0 6.9e-08 0 6.905e-08 0 7.2e-08 0 7.205e-08 0 7.5e-08 0 7.505e-08 0 7.8e-08 0 7.805e-08 0 8.1e-08 0 8.105e-08 0 8.4e-08 0 8.405e-08 0 8.7e-08 0 8.705e-08 0 9e-08 0 9.005e-08 0 9.3e-08 0 9.305e-08 0 9.6e-08 0 9.605e-08 3.3 9.9e-08 3.3 9.905e-08 3.3 1.02e-07 3.3 1.021e-07 3.3 1.05e-07 3.3 1.051e-07 3.3 1.08e-07 3.3 1.081e-07 3.3 1.11e-07 3.3 1.111e-07 3.3 1.14e-07 3.3 1.141e-07 3.3 1.17e-07 3.3 1.171e-07 3.3 1.2e-07 3.3 1.2e-07 3.3 1.23e-07 3.3 1.231e-07 3.3 1.26e-07 3.3 1.26e-07 3.3 1.29e-07 3.3 1.291e-07 3.3 1.32e-07 3.3 1.32e-07 3.3 1.35e-07 3.3 1.351e-07 3.3 1.38e-07 3.3 1.38e-07 3.3 1.41e-07 3.3 1.411e-07 3.3 1.44e-07 3.3 1.44e-07 3.3 1.47e-07 3.3 1.471e-07 3.3 1.5e-07 3.3 1.5e-07 3.3 1.53e-07 3.3 1.531e-07 3.3 1.56e-07 3.3 1.56e-07 3.3 1.59e-07 3.3 1.591e-07 3.3 1.62e-07 3.3 1.62e-07 3.3 1.65e-07 3.3 1.651e-07 3.3 1.68e-07 3.3 1.68e-07 3.3 1.71e-07 3.3 1.711e-07 3.3 1.74e-07 3.3 1.741e-07 3.3 1.77e-07 3.3 1.771e-07 3.3 1.8e-07 3.3 1.801e-07 3.3 1.83e-07 3.3 1.831e-07 3.3 1.86e-07 3.3 1.861e-07 3.3 1.89e-07 3.3 1.891e-07 3.3 1.92e-07 3.3 1.921e-07 3.3 1.95e-07 3.3 1.95e-07 3.3 1.98e-07 3.3 1.981e-07 3.3 2.01e-07 3.3 2.01e-07 3.3 2.04e-07 3.3 2.041e-07 3.3 2.07e-07 3.3 2.07e-07 3.3 2.1e-07 3.3 2.101e-07 3.3 2.13e-07 3.3 2.13e-07 3.3 2.16e-07 3.3 2.161e-07 3.3 2.19e-07 3.3 2.19e-07 3.3 2.22e-07 3.3 2.221e-07 3.3 2.25e-07 3.3 2.25e-07 3.3 2.28e-07 3.3 2.281e-07 3.3 2.31e-07 3.3 2.31e-07 3.3 2.34e-07 3.3 2.341e-07 3.3 2.37e-07 3.3 2.37e-07 3.3 2.4e-07 3.3 2.4e-07 3.3 2.43e-07 3.3 2.43e-07 3.3 2.46e-07 3.3 2.461e-07 3.3 2.49e-07 3.3 2.491e-07 3.3 2.52e-07 3.3 2.52e-07 3.3 2.55e-07 3.3 2.55e-07 3.3 2.58e-07 3.3 2.581e-07 3.3 2.61e-07 3.3 2.611e-07 3.3 2.64e-07 3.3 2.64e-07 3.3 2.67e-07 3.3 2.67e-07 3.3 2.7e-07 3.3 2.701e-07 3.3 2.73e-07 3.3 2.731e-07 3.3 2.76e-07 3.3 2.76e-07 3.3 2.79e-07 3.3 2.791e-07 3.3 2.82e-07 3.3 2.821e-07 3.3 2.85e-07 3.3 2.851e-07 3.3 2.88e-07 3.3 2.88e-07 0 2.91e-07 0 2.911e-07 0 2.94e-07 0 2.941e-07 0 2.97e-07 0 2.97e-07 0 3e-07 0 3e-07 0 3.03e-07 0 3.031e-07 0 3.06e-07 0 3.061e-07 0 3.09e-07 0 3.09e-07 0 3.12e-07 0 3.12e-07 0 3.15e-07 0 3.151e-07 0 3.18e-07 0 3.181e-07 0 3.21e-07 0 3.21e-07 0 3.24e-07 0 3.24e-07 0 3.27e-07 0 3.271e-07 0 3.3e-07 0 3.301e-07 0 3.33e-07 0 3.33e-07 0 3.36e-07 0 3.36e-07 0 3.39e-07 0 3.391e-07 0 3.42e-07 0 3.421e-07 0 3.45e-07 0 3.45e-07 0 3.48e-07 0 3.48e-07 0 3.51e-07 0 3.511e-07 0 3.54e-07 0 3.541e-07 0 3.57e-07 0 3.57e-07 0 3.6e-07 0 3.6e-07 0 3.63e-07 0 3.631e-07 0 3.66e-07 0 3.661e-07 0 3.69e-07 0 3.69e-07 0 3.72e-07 0 3.72e-07 0 3.75e-07 0 3.751e-07 0 3.78e-07 0 3.781e-07 0 3.81e-07 0 3.81e-07 0 3.84e-07 0 3.841e-07 0 3.87e-07 0 3.871e-07 0 3.9e-07 0 3.9e-07 0 3.93e-07 0 3.93e-07 0 3.96e-07 0 3.961e-07 0 3.99e-07 0 3.991e-07 0 4.02e-07 0 4.02e-07 0 4.05e-07 0 4.05e-07 0 4.08e-07 0 4.081e-07 0 4.11e-07 0 4.111e-07 0 4.14e-07 0 4.14e-07 0 4.17e-07 0 4.17e-07 0 4.2e-07 0 4.201e-07 0 4.23e-07 0 4.231e-07 0 4.26e-07 0 4.26e-07 0 4.29e-07 0 4.29e-07 0 4.32e-07 0 4.321e-07 0 4.35e-07 0 4.351e-07 0 4.38e-07 0 4.38e-07 0 4.41e-07 0 4.41e-07 0 4.44e-07 0 4.441e-07 0 4.47e-07 0 4.471e-07 0 4.5e-07 0 4.5e-07 0 4.53e-07 0 4.53e-07 0 4.56e-07 0 4.561e-07 0 4.59e-07 0 4.591e-07 0 4.62e-07 0 4.62e-07 0 4.65e-07 0 4.65e-07 0 4.68e-07 0 4.681e-07 0 4.71e-07 0 4.711e-07 0 4.74e-07 0 4.74e-07 0 4.77e-07 0 4.771e-07 0 4.8e-07 0 4.8e-07 3.3 4.83e-07 3.3 4.83e-07 3.3 4.86e-07 3.3 4.86e-07 3.3 4.89e-07 3.3 4.891e-07 3.3 4.92e-07 3.3 4.921e-07 3.3 4.95e-07 3.3 4.951e-07 3.3 4.98e-07 3.3 4.981e-07 3.3 5.01e-07 3.3 5.01e-07 3.3 5.04e-07 3.3 5.04e-07 3.3 5.07e-07 3.3 5.07e-07 3.3 5.1e-07 3.3 5.1e-07 3.3 5.13e-07 3.3 5.131e-07 3.3 5.16e-07 3.3 5.161e-07 3.3 5.19e-07 3.3 5.191e-07 3.3 5.22e-07 3.3 5.221e-07 3.3 5.25e-07 3.3 5.25e-07 3.3 5.28e-07 3.3 5.28e-07 3.3 5.31e-07 3.3 5.31e-07 3.3 5.34e-07 3.3 5.34e-07 3.3 5.37e-07 3.3 5.371e-07 3.3 5.4e-07 3.3 5.401e-07 3.3 5.43e-07 3.3 5.431e-07 3.3 5.46e-07 3.3 5.461e-07 3.3 5.49e-07 3.3 5.49e-07 3.3 5.52e-07 3.3 5.52e-07 3.3 5.55e-07 3.3 5.55e-07 3.3 5.58e-07 3.3 5.58e-07 3.3 5.61e-07 3.3 5.611e-07 3.3 5.64e-07 3.3 5.641e-07 3.3 5.67e-07 3.3 5.671e-07 3.3 5.7e-07 3.3 5.701e-07 3.3 5.73e-07 3.3 5.73e-07 3.3 5.76e-07 3.3 5.76e-07 3.3 5.79e-07 3.3 5.79e-07 3.3 5.82e-07 3.3 5.821e-07 3.3 5.85e-07 3.3 5.851e-07 3.3 5.88e-07 3.3 5.881e-07 3.3 5.91e-07 3.3 5.911e-07 3.3 5.94e-07 3.3 5.94e-07 3.3 5.97e-07 3.3 5.97e-07 3.3 6e-07 3.3 6e-07 3.3 6.03e-07 3.3 6.03e-07 3.3 6.06e-07 3.3 6.061e-07 3.3 6.09e-07 3.3 6.091e-07 3.3 6.12e-07 3.3 6.121e-07 3.3 6.15e-07 3.3 6.151e-07 3.3 6.18e-07 3.3 6.18e-07 3.3 6.21e-07 3.3 6.21e-07 3.3 6.24e-07 3.3 6.24e-07 3.3 6.27e-07 3.3 6.27e-07 3.3 6.3e-07 3.3 6.301e-07 3.3 6.33e-07 3.3 6.331e-07 3.3 6.36e-07 3.3 6.361e-07 3.3 6.39e-07 3.3 6.391e-07 3.3 6.42e-07 3.3 6.42e-07 3.3 6.45e-07 3.3 6.45e-07 3.3 6.48e-07 3.3 6.48e-07 3.3 6.51e-07 3.3 6.51e-07 3.3 6.54e-07 3.3 6.541e-07 3.3 6.57e-07 3.3 6.571e-07 3.3 6.6e-07 3.3 6.601e-07 3.3 6.63e-07 3.3 6.631e-07 3.3 6.66e-07 3.3 6.66e-07 3.3 6.69e-07 3.3 6.69e-07 3.3 6.72e-07 3.3 6.72e-07 0 6.75e-07 0 6.75e-07 0 6.78e-07 0 6.781e-07 0 6.81e-07 0 6.811e-07 0 6.84e-07 0 6.841e-07 0 6.87e-07 0 6.87e-07 0 6.9e-07 0 6.9e-07 0 6.93e-07 0 6.93e-07 0 6.96e-07 0 6.96e-07 0 6.99e-07 0 6.991e-07 0 7.02e-07 0 7.021e-07 0 7.05e-07 0 7.051e-07 0 7.08e-07 0 7.081e-07 0 7.11e-07 0 7.11e-07 0 7.14e-07 0 7.14e-07 0 7.17e-07 0 7.17e-07 0 7.2e-07 0 7.2e-07 0 7.23e-07 0 7.231e-07 0 7.26e-07 0 7.261e-07 0 7.29e-07 0 7.291e-07 0 7.32e-07 0 7.321e-07 0 7.35e-07 0 7.35e-07 0 7.38e-07 0 7.38e-07 0 7.41e-07 0 7.41e-07 0 7.44e-07 0 7.44e-07 0 7.47e-07 0 7.471e-07 0 7.5e-07 0 7.501e-07 0 7.53e-07 0 7.531e-07 0 7.56e-07 0 7.561e-07 0 7.59e-07 0 7.59e-07 0 7.62e-07 0 7.62e-07 0 7.65e-07 0 7.65e-07 0 7.68e-07 0 7.68e-07 0 7.71e-07 0 7.711e-07 0 7.74e-07 0 7.741e-07 0 7.77e-07 0 7.771e-07 0 7.8e-07 0 7.8e-07 0 7.83e-07 0 7.83e-07 0 7.86e-07 0 7.86e-07 0 7.89e-07 0 7.89e-07 0 7.92e-07 0 7.921e-07 0 7.95e-07 0 7.951e-07 0 7.98e-07 0 7.981e-07 0 8.01e-07 0 8.011e-07 0 8.04e-07 0 8.04e-07 0 8.07e-07 0 8.07e-07 0 8.1e-07 0 8.1e-07 0 8.13e-07 0 8.13e-07 0 8.16e-07 0 8.161e-07 0 8.19e-07 0 8.191e-07 0 8.22e-07 0 8.221e-07 0 8.25e-07 0 8.251e-07 0 8.28e-07 0 8.28e-07 0 8.31e-07 0 8.31e-07 0 8.34e-07 0 8.34e-07 0 8.37e-07 0 8.37e-07 0 8.4e-07 0 8.401e-07 0 8.43e-07 0 8.431e-07 0 8.46e-07 0 8.461e-07 0 8.49e-07 0 8.491e-07 0 8.52e-07 0 8.52e-07 0 8.55e-07 0 8.55e-07 0 8.58e-07 0 8.58e-07 0 8.61e-07 0 8.61e-07 0 8.64e-07 0 8.641e-07 3.3 8.67e-07 3.3 8.671e-07 3.3 8.7e-07 3.3 8.701e-07 3.3 8.73e-07 3.3 8.73e-07 3.3 8.76e-07 3.3 8.76e-07 3.3 8.79e-07 3.3 8.79e-07 3.3 8.82e-07 3.3 8.82e-07 3.3 8.85e-07 3.3 8.851e-07 3.3 8.88e-07 3.3 8.881e-07 3.3 8.91e-07 3.3 8.911e-07 3.3 8.94e-07 3.3 8.941e-07 3.3 8.97e-07 3.3 8.97e-07 3.3 9e-07 3.3 9e-07 3.3 9.03e-07 3.3 9.03e-07 3.3 9.06e-07 3.3 9.06e-07 3.3 9.09e-07 3.3 9.091e-07 3.3 9.12e-07 3.3 9.121e-07 3.3 9.15e-07 3.3 9.151e-07 3.3 9.18e-07 3.3 9.181e-07 3.3 9.21e-07 3.3 9.21e-07 3.3 9.24e-07 3.3 9.24e-07 3.3 9.27e-07 3.3 9.27e-07 3.3 9.3e-07 3.3 9.3e-07 3.3 9.33e-07 3.3 9.331e-07 3.3 9.36e-07 3.3 9.361e-07 3.3 9.39e-07 3.3 9.391e-07 3.3 9.42e-07 3.3 9.421e-07 3.3 9.45e-07 3.3 9.45e-07 3.3 9.48e-07 3.3 9.48e-07 3.3 9.51e-07 3.3 9.51e-07 3.3 9.54e-07 3.3 9.54e-07 3.3 9.57e-07 3.3 9.57e-07 3.3 9.6e-07 3.3 9.6e-07 3.3 9.63e-07 3.3 9.63e-07 3.3 9.66e-07 3.3 9.66e-07 3.3 9.69e-07 3.3 9.69e-07 3.3 9.72e-07 3.3 9.72e-07 3.3 9.75e-07 3.3 9.75e-07 3.3 9.78e-07 3.3 9.78e-07 3.3 9.81e-07 3.3 9.81e-07 3.3 9.84e-07 3.3 9.84e-07 3.3 9.87e-07 3.3 9.87e-07 3.3 9.9e-07 3.3 9.9e-07 3.3 9.93e-07 3.3 9.93e-07 3.3 9.96e-07 3.3 9.96e-07 3.3 9.99e-07 3.3 9.99e-07 3.3 1.002e-06 3.3 1.002e-06 3.3 1.005e-06 3.3 1.005e-06 3.3 1.008e-06 3.3 1.008e-06 3.3 1.011e-06 3.3 1.011e-06 3.3 1.014e-06 3.3 1.014e-06 3.3 1.017e-06 3.3 1.017e-06 3.3 1.02e-06 3.3 1.02e-06 3.3 1.023e-06 3.3 1.023e-06 3.3 1.026e-06 3.3 1.026e-06 3.3 1.029e-06 3.3 1.029e-06 3.3 1.032e-06 3.3 1.032e-06 3.3 1.035e-06 3.3 1.035e-06 3.3 1.038e-06 3.3 1.038e-06 3.3 1.041e-06 3.3 1.041e-06 3.3 1.044e-06 3.3 1.044e-06 3.3 1.047e-06 3.3 1.047e-06 3.3 1.05e-06 3.3 1.05e-06 3.3 1.053e-06 3.3 1.053e-06 3.3 1.056e-06 3.3 1.056e-06 0 1.059e-06 0 1.059e-06 0 1.062e-06 0 1.062e-06 0 1.065e-06 0 1.065e-06 0 1.068e-06 0 1.068e-06 0 1.071e-06 0 1.071e-06 0 1.074e-06 0 1.074e-06 0 1.077e-06 0 1.077e-06 0 1.08e-06 0 1.08e-06 0 1.083e-06 0 1.083e-06 0 1.086e-06 0 1.086e-06 0 1.089e-06 0 1.089e-06 0 1.092e-06 0 1.092e-06 0 1.095e-06 0 1.095e-06 0 1.098e-06 0 1.098e-06 0 1.101e-06 0 1.101e-06 0 1.104e-06 0 1.104e-06 0 1.107e-06 0 1.107e-06 0 1.11e-06 0 1.11e-06 0 1.113e-06 0 1.113e-06 0 1.116e-06 0 1.116e-06 0 1.119e-06 0 1.119e-06 0 1.122e-06 0 1.122e-06 0 1.125e-06 0 1.125e-06 0 1.128e-06 0 1.128e-06 0 1.131e-06 0 1.131e-06 0 1.134e-06 0 1.134e-06 0 1.137e-06 0 1.137e-06 0 1.14e-06 0 1.14e-06 0 1.143e-06 0 1.143e-06 0 1.146e-06 0 1.146e-06 0 1.149e-06 0 1.149e-06 0 1.152e-06 0 1.152e-06 0 1.155e-06 0 1.155e-06 0 1.158e-06 0 1.158e-06 0 1.161e-06 0 1.161e-06 0 1.164e-06 0 1.164e-06 0 1.167e-06 0 1.167e-06 0 1.17e-06 0 1.17e-06 0 1.173e-06 0 1.173e-06 0 1.176e-06 0 1.176e-06 0 1.179e-06 0 1.179e-06 0 1.182e-06 0 1.182e-06 0 1.185e-06 0 1.185e-06 0 1.188e-06 0 1.188e-06 0 1.191e-06 0 1.191e-06 0 1.194e-06 0 1.194e-06 0 1.197e-06 0 1.197e-06 0 1.2e-06 0 1.2e-06 0 1.203e-06 0 1.203e-06 0 1.206e-06 0 1.206e-06 0 1.209e-06 0 1.209e-06 0 1.212e-06 0 1.212e-06 0 1.215e-06 0 1.215e-06 0 1.218e-06 0 1.218e-06 0 1.221e-06 0 1.221e-06 0 1.224e-06 0 1.224e-06 0 1.227e-06 0 1.227e-06 0 1.23e-06 0 1.23e-06 0 1.233e-06 0 1.233e-06 0 1.236e-06 0 1.236e-06 0 1.239e-06 0 1.239e-06 0 1.242e-06 0 1.242e-06 0 1.245e-06 0 1.245e-06 0 1.248e-06 0 1.248e-06 3.3 1.251e-06 3.3 1.251e-06 3.3 1.254e-06 3.3 1.254e-06 3.3 1.257e-06 3.3 1.257e-06 3.3 1.26e-06 3.3 1.26e-06 3.3 1.263e-06 3.3 1.263e-06 3.3 1.266e-06 3.3 1.266e-06 3.3 1.269e-06 3.3 1.269e-06 3.3 1.272e-06 3.3 1.272e-06 3.3 1.275e-06 3.3 1.275e-06 3.3 1.278e-06 3.3 1.278e-06 3.3 1.281e-06 3.3 1.281e-06 3.3 1.284e-06 3.3 1.284e-06 3.3 1.287e-06 3.3 1.287e-06 3.3 1.29e-06 3.3 1.29e-06 3.3 1.293e-06 3.3 1.293e-06 3.3 1.296e-06 3.3 1.296e-06 3.3 1.299e-06 3.3 1.299e-06 3.3 1.302e-06 3.3 1.302e-06 3.3 1.305e-06 3.3 1.305e-06 3.3 1.308e-06 3.3 1.308e-06 3.3 1.311e-06 3.3 1.311e-06 3.3 1.314e-06 3.3 1.314e-06 3.3 1.317e-06 3.3 1.317e-06 3.3 1.32e-06 3.3 1.32e-06 3.3 1.323e-06 3.3 1.323e-06 3.3 1.326e-06 3.3 1.326e-06 3.3 1.329e-06 3.3 1.329e-06 3.3 1.332e-06 3.3 1.332e-06 3.3 1.335e-06 3.3 1.335e-06 3.3 1.338e-06 3.3 1.338e-06 3.3 1.341e-06 3.3 1.341e-06 3.3 1.344e-06 3.3 1.344e-06 3.3 1.347e-06 3.3 1.347e-06 3.3 1.35e-06 3.3 1.35e-06 3.3 1.353e-06 3.3 1.353e-06 3.3 1.356e-06 3.3 1.356e-06 3.3 1.359e-06 3.3 1.359e-06 3.3 1.362e-06 3.3 1.362e-06 3.3 1.365e-06 3.3 1.365e-06 3.3 1.368e-06 3.3 1.368e-06 3.3 1.371e-06 3.3 1.371e-06 3.3 1.374e-06 3.3 1.374e-06 3.3 1.377e-06 3.3 1.377e-06 3.3 1.38e-06 3.3 1.38e-06 3.3 1.383e-06 3.3 1.383e-06 3.3 1.386e-06 3.3 1.386e-06 3.3 1.389e-06 3.3 1.389e-06 3.3 1.392e-06 3.3 1.392e-06 3.3 1.395e-06 3.3 1.395e-06 3.3 1.398e-06 3.3 1.398e-06 3.3 1.401e-06 3.3 1.401e-06 3.3 1.404e-06 3.3 1.404e-06 3.3 1.407e-06 3.3 1.407e-06 3.3 1.41e-06 3.3 1.41e-06 3.3 1.413e-06 3.3 1.413e-06 3.3 1.416e-06 3.3 1.416e-06 3.3 1.419e-06 3.3 1.419e-06 3.3 1.422e-06 3.3 1.422e-06 3.3 1.425e-06 3.3 1.425e-06 3.3 1.428e-06 3.3 1.428e-06 3.3 1.431e-06 3.3 1.431e-06 3.3 1.434e-06 3.3 1.434e-06 3.3 1.437e-06 3.3 1.437e-06 3.3 1.44e-06 3.3 1.44e-06 0 1.443e-06 0 1.443e-06 0 1.446e-06 0 1.446e-06 0 1.449e-06 0 1.449e-06 0 1.452e-06 0 1.452e-06 0 1.455e-06 0 1.455e-06 0 1.458e-06 0 1.458e-06 0 1.461e-06 0 1.461e-06 0 1.464e-06 0 1.464e-06 0 1.467e-06 0 1.467e-06 0 1.47e-06 0 1.47e-06 0 1.473e-06 0 1.473e-06 0 1.476e-06 0 1.476e-06 0 1.479e-06 0 1.479e-06 0 1.482e-06 0 1.482e-06 0 1.485e-06 0 1.485e-06 0 1.488e-06 0 1.488e-06 0 1.491e-06 0 1.491e-06 0 1.494e-06 0 1.494e-06 0 1.497e-06 0 1.497e-06 0 1.5e-06 0 1.5e-06 0 1.503e-06 0 1.503e-06 0 1.506e-06 0 1.506e-06 0 1.509e-06 0 1.509e-06 0 1.512e-06 0 1.512e-06 0 1.515e-06 0 1.515e-06 0 1.518e-06 0 1.518e-06 0 1.521e-06 0 1.521e-06 0 1.524e-06 0 1.524e-06 0 1.527e-06 0 1.527e-06 0 1.53e-06 0 1.53e-06 0 1.533e-06 0 1.533e-06 0)
VB2 B2 0 PWL(0 0 3e-09 0 3.05e-09 0 6e-09 0 6.05e-09 0 9e-09 0 9.05e-09 0 1.2e-08 0 1.205e-08 0 1.5e-08 0 1.505e-08 0 1.8e-08 0 1.805e-08 0 2.1e-08 0 2.105e-08 0 2.4e-08 0 2.405e-08 0 2.7e-08 0 2.705e-08 0 3e-08 0 3.005e-08 0 3.3e-08 0 3.305e-08 0 3.6e-08 0 3.605e-08 0 3.9e-08 0 3.905e-08 0 4.2e-08 0 4.205e-08 0 4.5e-08 0 4.505e-08 0 4.8e-08 0 4.805e-08 0 5.1e-08 0 5.105e-08 0 5.4e-08 0 5.405e-08 0 5.7e-08 0 5.705e-08 0 6e-08 0 6.005e-08 0 6.3e-08 0 6.305e-08 0 6.6e-08 0 6.605e-08 0 6.9e-08 0 6.905e-08 0 7.2e-08 0 7.205e-08 0 7.5e-08 0 7.505e-08 0 7.8e-08 0 7.805e-08 0 8.1e-08 0 8.105e-08 0 8.4e-08 0 8.405e-08 0 8.7e-08 0 8.705e-08 0 9e-08 0 9.005e-08 0 9.3e-08 0 9.305e-08 0 9.6e-08 0 9.605e-08 0 9.9e-08 0 9.905e-08 0 1.02e-07 0 1.021e-07 0 1.05e-07 0 1.051e-07 0 1.08e-07 0 1.081e-07 0 1.11e-07 0 1.111e-07 0 1.14e-07 0 1.141e-07 0 1.17e-07 0 1.171e-07 0 1.2e-07 0 1.2e-07 0 1.23e-07 0 1.231e-07 0 1.26e-07 0 1.26e-07 0 1.29e-07 0 1.291e-07 0 1.32e-07 0 1.32e-07 0 1.35e-07 0 1.351e-07 0 1.38e-07 0 1.38e-07 0 1.41e-07 0 1.411e-07 0 1.44e-07 0 1.44e-07 0 1.47e-07 0 1.471e-07 0 1.5e-07 0 1.5e-07 0 1.53e-07 0 1.531e-07 0 1.56e-07 0 1.56e-07 0 1.59e-07 0 1.591e-07 0 1.62e-07 0 1.62e-07 0 1.65e-07 0 1.651e-07 0 1.68e-07 0 1.68e-07 0 1.71e-07 0 1.711e-07 0 1.74e-07 0 1.741e-07 0 1.77e-07 0 1.771e-07 0 1.8e-07 0 1.801e-07 0 1.83e-07 0 1.831e-07 0 1.86e-07 0 1.861e-07 0 1.89e-07 0 1.891e-07 0 1.92e-07 0 1.921e-07 3.3 1.95e-07 3.3 1.95e-07 3.3 1.98e-07 3.3 1.981e-07 3.3 2.01e-07 3.3 2.01e-07 3.3 2.04e-07 3.3 2.041e-07 3.3 2.07e-07 3.3 2.07e-07 3.3 2.1e-07 3.3 2.101e-07 3.3 2.13e-07 3.3 2.13e-07 3.3 2.16e-07 3.3 2.161e-07 3.3 2.19e-07 3.3 2.19e-07 3.3 2.22e-07 3.3 2.221e-07 3.3 2.25e-07 3.3 2.25e-07 3.3 2.28e-07 3.3 2.281e-07 3.3 2.31e-07 3.3 2.31e-07 3.3 2.34e-07 3.3 2.341e-07 3.3 2.37e-07 3.3 2.37e-07 3.3 2.4e-07 3.3 2.4e-07 3.3 2.43e-07 3.3 2.43e-07 3.3 2.46e-07 3.3 2.461e-07 3.3 2.49e-07 3.3 2.491e-07 3.3 2.52e-07 3.3 2.52e-07 3.3 2.55e-07 3.3 2.55e-07 3.3 2.58e-07 3.3 2.581e-07 3.3 2.61e-07 3.3 2.611e-07 3.3 2.64e-07 3.3 2.64e-07 3.3 2.67e-07 3.3 2.67e-07 3.3 2.7e-07 3.3 2.701e-07 3.3 2.73e-07 3.3 2.731e-07 3.3 2.76e-07 3.3 2.76e-07 3.3 2.79e-07 3.3 2.791e-07 3.3 2.82e-07 3.3 2.821e-07 3.3 2.85e-07 3.3 2.851e-07 3.3 2.88e-07 3.3 2.88e-07 3.3 2.91e-07 3.3 2.911e-07 3.3 2.94e-07 3.3 2.941e-07 3.3 2.97e-07 3.3 2.97e-07 3.3 3e-07 3.3 3e-07 3.3 3.03e-07 3.3 3.031e-07 3.3 3.06e-07 3.3 3.061e-07 3.3 3.09e-07 3.3 3.09e-07 3.3 3.12e-07 3.3 3.12e-07 3.3 3.15e-07 3.3 3.151e-07 3.3 3.18e-07 3.3 3.181e-07 3.3 3.21e-07 3.3 3.21e-07 3.3 3.24e-07 3.3 3.24e-07 3.3 3.27e-07 3.3 3.271e-07 3.3 3.3e-07 3.3 3.301e-07 3.3 3.33e-07 3.3 3.33e-07 3.3 3.36e-07 3.3 3.36e-07 3.3 3.39e-07 3.3 3.391e-07 3.3 3.42e-07 3.3 3.421e-07 3.3 3.45e-07 3.3 3.45e-07 3.3 3.48e-07 3.3 3.48e-07 3.3 3.51e-07 3.3 3.511e-07 3.3 3.54e-07 3.3 3.541e-07 3.3 3.57e-07 3.3 3.57e-07 3.3 3.6e-07 3.3 3.6e-07 3.3 3.63e-07 3.3 3.631e-07 3.3 3.66e-07 3.3 3.661e-07 3.3 3.69e-07 3.3 3.69e-07 3.3 3.72e-07 3.3 3.72e-07 3.3 3.75e-07 3.3 3.751e-07 3.3 3.78e-07 3.3 3.781e-07 3.3 3.81e-07 3.3 3.81e-07 3.3 3.84e-07 3.3 3.841e-07 3.3 3.87e-07 3.3 3.871e-07 3.3 3.9e-07 3.3 3.9e-07 3.3 3.93e-07 3.3 3.93e-07 3.3 3.96e-07 3.3 3.961e-07 3.3 3.99e-07 3.3 3.991e-07 3.3 4.02e-07 3.3 4.02e-07 3.3 4.05e-07 3.3 4.05e-07 3.3 4.08e-07 3.3 4.081e-07 3.3 4.11e-07 3.3 4.111e-07 3.3 4.14e-07 3.3 4.14e-07 3.3 4.17e-07 3.3 4.17e-07 3.3 4.2e-07 3.3 4.201e-07 3.3 4.23e-07 3.3 4.231e-07 3.3 4.26e-07 3.3 4.26e-07 3.3 4.29e-07 3.3 4.29e-07 3.3 4.32e-07 3.3 4.321e-07 3.3 4.35e-07 3.3 4.351e-07 3.3 4.38e-07 3.3 4.38e-07 3.3 4.41e-07 3.3 4.41e-07 3.3 4.44e-07 3.3 4.441e-07 3.3 4.47e-07 3.3 4.471e-07 3.3 4.5e-07 3.3 4.5e-07 3.3 4.53e-07 3.3 4.53e-07 3.3 4.56e-07 3.3 4.561e-07 3.3 4.59e-07 3.3 4.591e-07 3.3 4.62e-07 3.3 4.62e-07 3.3 4.65e-07 3.3 4.65e-07 3.3 4.68e-07 3.3 4.681e-07 3.3 4.71e-07 3.3 4.711e-07 3.3 4.74e-07 3.3 4.74e-07 3.3 4.77e-07 3.3 4.771e-07 3.3 4.8e-07 3.3 4.8e-07 3.3 4.83e-07 3.3 4.83e-07 3.3 4.86e-07 3.3 4.86e-07 3.3 4.89e-07 3.3 4.891e-07 3.3 4.92e-07 3.3 4.921e-07 3.3 4.95e-07 3.3 4.951e-07 3.3 4.98e-07 3.3 4.981e-07 3.3 5.01e-07 3.3 5.01e-07 3.3 5.04e-07 3.3 5.04e-07 3.3 5.07e-07 3.3 5.07e-07 3.3 5.1e-07 3.3 5.1e-07 3.3 5.13e-07 3.3 5.131e-07 3.3 5.16e-07 3.3 5.161e-07 3.3 5.19e-07 3.3 5.191e-07 3.3 5.22e-07 3.3 5.221e-07 3.3 5.25e-07 3.3 5.25e-07 3.3 5.28e-07 3.3 5.28e-07 3.3 5.31e-07 3.3 5.31e-07 3.3 5.34e-07 3.3 5.34e-07 3.3 5.37e-07 3.3 5.371e-07 3.3 5.4e-07 3.3 5.401e-07 3.3 5.43e-07 3.3 5.431e-07 3.3 5.46e-07 3.3 5.461e-07 3.3 5.49e-07 3.3 5.49e-07 3.3 5.52e-07 3.3 5.52e-07 3.3 5.55e-07 3.3 5.55e-07 3.3 5.58e-07 3.3 5.58e-07 3.3 5.61e-07 3.3 5.611e-07 3.3 5.64e-07 3.3 5.641e-07 3.3 5.67e-07 3.3 5.671e-07 3.3 5.7e-07 3.3 5.701e-07 3.3 5.73e-07 3.3 5.73e-07 3.3 5.76e-07 3.3 5.76e-07 0 5.79e-07 0 5.79e-07 0 5.82e-07 0 5.821e-07 0 5.85e-07 0 5.851e-07 0 5.88e-07 0 5.881e-07 0 5.91e-07 0 5.911e-07 0 5.94e-07 0 5.94e-07 0 5.97e-07 0 5.97e-07 0 6e-07 0 6e-07 0 6.03e-07 0 6.03e-07 0 6.06e-07 0 6.061e-07 0 6.09e-07 0 6.091e-07 0 6.12e-07 0 6.121e-07 0 6.15e-07 0 6.151e-07 0 6.18e-07 0 6.18e-07 0 6.21e-07 0 6.21e-07 0 6.24e-07 0 6.24e-07 0 6.27e-07 0 6.27e-07 0 6.3e-07 0 6.301e-07 0 6.33e-07 0 6.331e-07 0 6.36e-07 0 6.361e-07 0 6.39e-07 0 6.391e-07 0 6.42e-07 0 6.42e-07 0 6.45e-07 0 6.45e-07 0 6.48e-07 0 6.48e-07 0 6.51e-07 0 6.51e-07 0 6.54e-07 0 6.541e-07 0 6.57e-07 0 6.571e-07 0 6.6e-07 0 6.601e-07 0 6.63e-07 0 6.631e-07 0 6.66e-07 0 6.66e-07 0 6.69e-07 0 6.69e-07 0 6.72e-07 0 6.72e-07 0 6.75e-07 0 6.75e-07 0 6.78e-07 0 6.781e-07 0 6.81e-07 0 6.811e-07 0 6.84e-07 0 6.841e-07 0 6.87e-07 0 6.87e-07 0 6.9e-07 0 6.9e-07 0 6.93e-07 0 6.93e-07 0 6.96e-07 0 6.96e-07 0 6.99e-07 0 6.991e-07 0 7.02e-07 0 7.021e-07 0 7.05e-07 0 7.051e-07 0 7.08e-07 0 7.081e-07 0 7.11e-07 0 7.11e-07 0 7.14e-07 0 7.14e-07 0 7.17e-07 0 7.17e-07 0 7.2e-07 0 7.2e-07 0 7.23e-07 0 7.231e-07 0 7.26e-07 0 7.261e-07 0 7.29e-07 0 7.291e-07 0 7.32e-07 0 7.321e-07 0 7.35e-07 0 7.35e-07 0 7.38e-07 0 7.38e-07 0 7.41e-07 0 7.41e-07 0 7.44e-07 0 7.44e-07 0 7.47e-07 0 7.471e-07 0 7.5e-07 0 7.501e-07 0 7.53e-07 0 7.531e-07 0 7.56e-07 0 7.561e-07 0 7.59e-07 0 7.59e-07 0 7.62e-07 0 7.62e-07 0 7.65e-07 0 7.65e-07 0 7.68e-07 0 7.68e-07 0 7.71e-07 0 7.711e-07 0 7.74e-07 0 7.741e-07 0 7.77e-07 0 7.771e-07 0 7.8e-07 0 7.8e-07 0 7.83e-07 0 7.83e-07 0 7.86e-07 0 7.86e-07 0 7.89e-07 0 7.89e-07 0 7.92e-07 0 7.921e-07 0 7.95e-07 0 7.951e-07 0 7.98e-07 0 7.981e-07 0 8.01e-07 0 8.011e-07 0 8.04e-07 0 8.04e-07 0 8.07e-07 0 8.07e-07 0 8.1e-07 0 8.1e-07 0 8.13e-07 0 8.13e-07 0 8.16e-07 0 8.161e-07 0 8.19e-07 0 8.191e-07 0 8.22e-07 0 8.221e-07 0 8.25e-07 0 8.251e-07 0 8.28e-07 0 8.28e-07 0 8.31e-07 0 8.31e-07 0 8.34e-07 0 8.34e-07 0 8.37e-07 0 8.37e-07 0 8.4e-07 0 8.401e-07 0 8.43e-07 0 8.431e-07 0 8.46e-07 0 8.461e-07 0 8.49e-07 0 8.491e-07 0 8.52e-07 0 8.52e-07 0 8.55e-07 0 8.55e-07 0 8.58e-07 0 8.58e-07 0 8.61e-07 0 8.61e-07 0 8.64e-07 0 8.641e-07 0 8.67e-07 0 8.671e-07 0 8.7e-07 0 8.701e-07 0 8.73e-07 0 8.73e-07 0 8.76e-07 0 8.76e-07 0 8.79e-07 0 8.79e-07 0 8.82e-07 0 8.82e-07 0 8.85e-07 0 8.851e-07 0 8.88e-07 0 8.881e-07 0 8.91e-07 0 8.911e-07 0 8.94e-07 0 8.941e-07 0 8.97e-07 0 8.97e-07 0 9e-07 0 9e-07 0 9.03e-07 0 9.03e-07 0 9.06e-07 0 9.06e-07 0 9.09e-07 0 9.091e-07 0 9.12e-07 0 9.121e-07 0 9.15e-07 0 9.151e-07 0 9.18e-07 0 9.181e-07 0 9.21e-07 0 9.21e-07 0 9.24e-07 0 9.24e-07 0 9.27e-07 0 9.27e-07 0 9.3e-07 0 9.3e-07 0 9.33e-07 0 9.331e-07 0 9.36e-07 0 9.361e-07 0 9.39e-07 0 9.391e-07 0 9.42e-07 0 9.421e-07 0 9.45e-07 0 9.45e-07 0 9.48e-07 0 9.48e-07 0 9.51e-07 0 9.51e-07 0 9.54e-07 0 9.54e-07 0 9.57e-07 0 9.57e-07 0 9.6e-07 0 9.6e-07 3.3 9.63e-07 3.3 9.63e-07 3.3 9.66e-07 3.3 9.66e-07 3.3 9.69e-07 3.3 9.69e-07 3.3 9.72e-07 3.3 9.72e-07 3.3 9.75e-07 3.3 9.75e-07 3.3 9.78e-07 3.3 9.78e-07 3.3 9.81e-07 3.3 9.81e-07 3.3 9.84e-07 3.3 9.84e-07 3.3 9.87e-07 3.3 9.87e-07 3.3 9.9e-07 3.3 9.9e-07 3.3 9.93e-07 3.3 9.93e-07 3.3 9.96e-07 3.3 9.96e-07 3.3 9.99e-07 3.3 9.99e-07 3.3 1.002e-06 3.3 1.002e-06 3.3 1.005e-06 3.3 1.005e-06 3.3 1.008e-06 3.3 1.008e-06 3.3 1.011e-06 3.3 1.011e-06 3.3 1.014e-06 3.3 1.014e-06 3.3 1.017e-06 3.3 1.017e-06 3.3 1.02e-06 3.3 1.02e-06 3.3 1.023e-06 3.3 1.023e-06 3.3 1.026e-06 3.3 1.026e-06 3.3 1.029e-06 3.3 1.029e-06 3.3 1.032e-06 3.3 1.032e-06 3.3 1.035e-06 3.3 1.035e-06 3.3 1.038e-06 3.3 1.038e-06 3.3 1.041e-06 3.3 1.041e-06 3.3 1.044e-06 3.3 1.044e-06 3.3 1.047e-06 3.3 1.047e-06 3.3 1.05e-06 3.3 1.05e-06 3.3 1.053e-06 3.3 1.053e-06 3.3 1.056e-06 3.3 1.056e-06 3.3 1.059e-06 3.3 1.059e-06 3.3 1.062e-06 3.3 1.062e-06 3.3 1.065e-06 3.3 1.065e-06 3.3 1.068e-06 3.3 1.068e-06 3.3 1.071e-06 3.3 1.071e-06 3.3 1.074e-06 3.3 1.074e-06 3.3 1.077e-06 3.3 1.077e-06 3.3 1.08e-06 3.3 1.08e-06 3.3 1.083e-06 3.3 1.083e-06 3.3 1.086e-06 3.3 1.086e-06 3.3 1.089e-06 3.3 1.089e-06 3.3 1.092e-06 3.3 1.092e-06 3.3 1.095e-06 3.3 1.095e-06 3.3 1.098e-06 3.3 1.098e-06 3.3 1.101e-06 3.3 1.101e-06 3.3 1.104e-06 3.3 1.104e-06 3.3 1.107e-06 3.3 1.107e-06 3.3 1.11e-06 3.3 1.11e-06 3.3 1.113e-06 3.3 1.113e-06 3.3 1.116e-06 3.3 1.116e-06 3.3 1.119e-06 3.3 1.119e-06 3.3 1.122e-06 3.3 1.122e-06 3.3 1.125e-06 3.3 1.125e-06 3.3 1.128e-06 3.3 1.128e-06 3.3 1.131e-06 3.3 1.131e-06 3.3 1.134e-06 3.3 1.134e-06 3.3 1.137e-06 3.3 1.137e-06 3.3 1.14e-06 3.3 1.14e-06 3.3 1.143e-06 3.3 1.143e-06 3.3 1.146e-06 3.3 1.146e-06 3.3 1.149e-06 3.3 1.149e-06 3.3 1.152e-06 3.3 1.152e-06 3.3 1.155e-06 3.3 1.155e-06 3.3 1.158e-06 3.3 1.158e-06 3.3 1.161e-06 3.3 1.161e-06 3.3 1.164e-06 3.3 1.164e-06 3.3 1.167e-06 3.3 1.167e-06 3.3 1.17e-06 3.3 1.17e-06 3.3 1.173e-06 3.3 1.173e-06 3.3 1.176e-06 3.3 1.176e-06 3.3 1.179e-06 3.3 1.179e-06 3.3 1.182e-06 3.3 1.182e-06 3.3 1.185e-06 3.3 1.185e-06 3.3 1.188e-06 3.3 1.188e-06 3.3 1.191e-06 3.3 1.191e-06 3.3 1.194e-06 3.3 1.194e-06 3.3 1.197e-06 3.3 1.197e-06 3.3 1.2e-06 3.3 1.2e-06 3.3 1.203e-06 3.3 1.203e-06 3.3 1.206e-06 3.3 1.206e-06 3.3 1.209e-06 3.3 1.209e-06 3.3 1.212e-06 3.3 1.212e-06 3.3 1.215e-06 3.3 1.215e-06 3.3 1.218e-06 3.3 1.218e-06 3.3 1.221e-06 3.3 1.221e-06 3.3 1.224e-06 3.3 1.224e-06 3.3 1.227e-06 3.3 1.227e-06 3.3 1.23e-06 3.3 1.23e-06 3.3 1.233e-06 3.3 1.233e-06 3.3 1.236e-06 3.3 1.236e-06 3.3 1.239e-06 3.3 1.239e-06 3.3 1.242e-06 3.3 1.242e-06 3.3 1.245e-06 3.3 1.245e-06 3.3 1.248e-06 3.3 1.248e-06 3.3 1.251e-06 3.3 1.251e-06 3.3 1.254e-06 3.3 1.254e-06 3.3 1.257e-06 3.3 1.257e-06 3.3 1.26e-06 3.3 1.26e-06 3.3 1.263e-06 3.3 1.263e-06 3.3 1.266e-06 3.3 1.266e-06 3.3 1.269e-06 3.3 1.269e-06 3.3 1.272e-06 3.3 1.272e-06 3.3 1.275e-06 3.3 1.275e-06 3.3 1.278e-06 3.3 1.278e-06 3.3 1.281e-06 3.3 1.281e-06 3.3 1.284e-06 3.3 1.284e-06 3.3 1.287e-06 3.3 1.287e-06 3.3 1.29e-06 3.3 1.29e-06 3.3 1.293e-06 3.3 1.293e-06 3.3 1.296e-06 3.3 1.296e-06 3.3 1.299e-06 3.3 1.299e-06 3.3 1.302e-06 3.3 1.302e-06 3.3 1.305e-06 3.3 1.305e-06 3.3 1.308e-06 3.3 1.308e-06 3.3 1.311e-06 3.3 1.311e-06 3.3 1.314e-06 3.3 1.314e-06 3.3 1.317e-06 3.3 1.317e-06 3.3 1.32e-06 3.3 1.32e-06 3.3 1.323e-06 3.3 1.323e-06 3.3 1.326e-06 3.3 1.326e-06 3.3 1.329e-06 3.3 1.329e-06 3.3 1.332e-06 3.3 1.332e-06 3.3 1.335e-06 3.3 1.335e-06 3.3 1.338e-06 3.3 1.338e-06 3.3 1.341e-06 3.3 1.341e-06 3.3 1.344e-06 3.3 1.344e-06 0 1.347e-06 0 1.347e-06 0 1.35e-06 0 1.35e-06 0 1.353e-06 0 1.353e-06 0 1.356e-06 0 1.356e-06 0 1.359e-06 0 1.359e-06 0 1.362e-06 0 1.362e-06 0 1.365e-06 0 1.365e-06 0 1.368e-06 0 1.368e-06 0 1.371e-06 0 1.371e-06 0 1.374e-06 0 1.374e-06 0 1.377e-06 0 1.377e-06 0 1.38e-06 0 1.38e-06 0 1.383e-06 0 1.383e-06 0 1.386e-06 0 1.386e-06 0 1.389e-06 0 1.389e-06 0 1.392e-06 0 1.392e-06 0 1.395e-06 0 1.395e-06 0 1.398e-06 0 1.398e-06 0 1.401e-06 0 1.401e-06 0 1.404e-06 0 1.404e-06 0 1.407e-06 0 1.407e-06 0 1.41e-06 0 1.41e-06 0 1.413e-06 0 1.413e-06 0 1.416e-06 0 1.416e-06 0 1.419e-06 0 1.419e-06 0 1.422e-06 0 1.422e-06 0 1.425e-06 0 1.425e-06 0 1.428e-06 0 1.428e-06 0 1.431e-06 0 1.431e-06 0 1.434e-06 0 1.434e-06 0 1.437e-06 0 1.437e-06 0 1.44e-06 0 1.44e-06 0 1.443e-06 0 1.443e-06 0 1.446e-06 0 1.446e-06 0 1.449e-06 0 1.449e-06 0 1.452e-06 0 1.452e-06 0 1.455e-06 0 1.455e-06 0 1.458e-06 0 1.458e-06 0 1.461e-06 0 1.461e-06 0 1.464e-06 0 1.464e-06 0 1.467e-06 0 1.467e-06 0 1.47e-06 0 1.47e-06 0 1.473e-06 0 1.473e-06 0 1.476e-06 0 1.476e-06 0 1.479e-06 0 1.479e-06 0 1.482e-06 0 1.482e-06 0 1.485e-06 0 1.485e-06 0 1.488e-06 0 1.488e-06 0 1.491e-06 0 1.491e-06 0 1.494e-06 0 1.494e-06 0 1.497e-06 0 1.497e-06 0 1.5e-06 0 1.5e-06 0 1.503e-06 0 1.503e-06 0 1.506e-06 0 1.506e-06 0 1.509e-06 0 1.509e-06 0 1.512e-06 0 1.512e-06 0 1.515e-06 0 1.515e-06 0 1.518e-06 0 1.518e-06 0 1.521e-06 0 1.521e-06 0 1.524e-06 0 1.524e-06 0 1.527e-06 0 1.527e-06 0 1.53e-06 0 1.53e-06 0 1.533e-06 0 1.533e-06 0)
VB3 B3 0 PWL(0 0 3e-09 0 3.05e-09 0 6e-09 0 6.05e-09 0 9e-09 0 9.05e-09 0 1.2e-08 0 1.205e-08 0 1.5e-08 0 1.505e-08 0 1.8e-08 0 1.805e-08 0 2.1e-08 0 2.105e-08 0 2.4e-08 0 2.405e-08 0 2.7e-08 0 2.705e-08 0 3e-08 0 3.005e-08 0 3.3e-08 0 3.305e-08 0 3.6e-08 0 3.605e-08 0 3.9e-08 0 3.905e-08 0 4.2e-08 0 4.205e-08 0 4.5e-08 0 4.505e-08 0 4.8e-08 0 4.805e-08 0 5.1e-08 0 5.105e-08 0 5.4e-08 0 5.405e-08 0 5.7e-08 0 5.705e-08 0 6e-08 0 6.005e-08 0 6.3e-08 0 6.305e-08 0 6.6e-08 0 6.605e-08 0 6.9e-08 0 6.905e-08 0 7.2e-08 0 7.205e-08 0 7.5e-08 0 7.505e-08 0 7.8e-08 0 7.805e-08 0 8.1e-08 0 8.105e-08 0 8.4e-08 0 8.405e-08 0 8.7e-08 0 8.705e-08 0 9e-08 0 9.005e-08 0 9.3e-08 0 9.305e-08 0 9.6e-08 0 9.605e-08 0 9.9e-08 0 9.905e-08 0 1.02e-07 0 1.021e-07 0 1.05e-07 0 1.051e-07 0 1.08e-07 0 1.081e-07 0 1.11e-07 0 1.111e-07 0 1.14e-07 0 1.141e-07 0 1.17e-07 0 1.171e-07 0 1.2e-07 0 1.2e-07 0 1.23e-07 0 1.231e-07 0 1.26e-07 0 1.26e-07 0 1.29e-07 0 1.291e-07 0 1.32e-07 0 1.32e-07 0 1.35e-07 0 1.351e-07 0 1.38e-07 0 1.38e-07 0 1.41e-07 0 1.411e-07 0 1.44e-07 0 1.44e-07 0 1.47e-07 0 1.471e-07 0 1.5e-07 0 1.5e-07 0 1.53e-07 0 1.531e-07 0 1.56e-07 0 1.56e-07 0 1.59e-07 0 1.591e-07 0 1.62e-07 0 1.62e-07 0 1.65e-07 0 1.651e-07 0 1.68e-07 0 1.68e-07 0 1.71e-07 0 1.711e-07 0 1.74e-07 0 1.741e-07 0 1.77e-07 0 1.771e-07 0 1.8e-07 0 1.801e-07 0 1.83e-07 0 1.831e-07 0 1.86e-07 0 1.861e-07 0 1.89e-07 0 1.891e-07 0 1.92e-07 0 1.921e-07 0 1.95e-07 0 1.95e-07 0 1.98e-07 0 1.981e-07 0 2.01e-07 0 2.01e-07 0 2.04e-07 0 2.041e-07 0 2.07e-07 0 2.07e-07 0 2.1e-07 0 2.101e-07 0 2.13e-07 0 2.13e-07 0 2.16e-07 0 2.161e-07 0 2.19e-07 0 2.19e-07 0 2.22e-07 0 2.221e-07 0 2.25e-07 0 2.25e-07 0 2.28e-07 0 2.281e-07 0 2.31e-07 0 2.31e-07 0 2.34e-07 0 2.341e-07 0 2.37e-07 0 2.37e-07 0 2.4e-07 0 2.4e-07 0 2.43e-07 0 2.43e-07 0 2.46e-07 0 2.461e-07 0 2.49e-07 0 2.491e-07 0 2.52e-07 0 2.52e-07 0 2.55e-07 0 2.55e-07 0 2.58e-07 0 2.581e-07 0 2.61e-07 0 2.611e-07 0 2.64e-07 0 2.64e-07 0 2.67e-07 0 2.67e-07 0 2.7e-07 0 2.701e-07 0 2.73e-07 0 2.731e-07 0 2.76e-07 0 2.76e-07 0 2.79e-07 0 2.791e-07 0 2.82e-07 0 2.821e-07 0 2.85e-07 0 2.851e-07 0 2.88e-07 0 2.88e-07 0 2.91e-07 0 2.911e-07 0 2.94e-07 0 2.941e-07 0 2.97e-07 0 2.97e-07 0 3e-07 0 3e-07 0 3.03e-07 0 3.031e-07 0 3.06e-07 0 3.061e-07 0 3.09e-07 0 3.09e-07 0 3.12e-07 0 3.12e-07 0 3.15e-07 0 3.151e-07 0 3.18e-07 0 3.181e-07 0 3.21e-07 0 3.21e-07 0 3.24e-07 0 3.24e-07 0 3.27e-07 0 3.271e-07 0 3.3e-07 0 3.301e-07 0 3.33e-07 0 3.33e-07 0 3.36e-07 0 3.36e-07 0 3.39e-07 0 3.391e-07 0 3.42e-07 0 3.421e-07 0 3.45e-07 0 3.45e-07 0 3.48e-07 0 3.48e-07 0 3.51e-07 0 3.511e-07 0 3.54e-07 0 3.541e-07 0 3.57e-07 0 3.57e-07 0 3.6e-07 0 3.6e-07 0 3.63e-07 0 3.631e-07 0 3.66e-07 0 3.661e-07 0 3.69e-07 0 3.69e-07 0 3.72e-07 0 3.72e-07 0 3.75e-07 0 3.751e-07 0 3.78e-07 0 3.781e-07 0 3.81e-07 0 3.81e-07 0 3.84e-07 0 3.841e-07 3.3 3.87e-07 3.3 3.871e-07 3.3 3.9e-07 3.3 3.9e-07 3.3 3.93e-07 3.3 3.93e-07 3.3 3.96e-07 3.3 3.961e-07 3.3 3.99e-07 3.3 3.991e-07 3.3 4.02e-07 3.3 4.02e-07 3.3 4.05e-07 3.3 4.05e-07 3.3 4.08e-07 3.3 4.081e-07 3.3 4.11e-07 3.3 4.111e-07 3.3 4.14e-07 3.3 4.14e-07 3.3 4.17e-07 3.3 4.17e-07 3.3 4.2e-07 3.3 4.201e-07 3.3 4.23e-07 3.3 4.231e-07 3.3 4.26e-07 3.3 4.26e-07 3.3 4.29e-07 3.3 4.29e-07 3.3 4.32e-07 3.3 4.321e-07 3.3 4.35e-07 3.3 4.351e-07 3.3 4.38e-07 3.3 4.38e-07 3.3 4.41e-07 3.3 4.41e-07 3.3 4.44e-07 3.3 4.441e-07 3.3 4.47e-07 3.3 4.471e-07 3.3 4.5e-07 3.3 4.5e-07 3.3 4.53e-07 3.3 4.53e-07 3.3 4.56e-07 3.3 4.561e-07 3.3 4.59e-07 3.3 4.591e-07 3.3 4.62e-07 3.3 4.62e-07 3.3 4.65e-07 3.3 4.65e-07 3.3 4.68e-07 3.3 4.681e-07 3.3 4.71e-07 3.3 4.711e-07 3.3 4.74e-07 3.3 4.74e-07 3.3 4.77e-07 3.3 4.771e-07 3.3 4.8e-07 3.3 4.8e-07 3.3 4.83e-07 3.3 4.83e-07 3.3 4.86e-07 3.3 4.86e-07 3.3 4.89e-07 3.3 4.891e-07 3.3 4.92e-07 3.3 4.921e-07 3.3 4.95e-07 3.3 4.951e-07 3.3 4.98e-07 3.3 4.981e-07 3.3 5.01e-07 3.3 5.01e-07 3.3 5.04e-07 3.3 5.04e-07 3.3 5.07e-07 3.3 5.07e-07 3.3 5.1e-07 3.3 5.1e-07 3.3 5.13e-07 3.3 5.131e-07 3.3 5.16e-07 3.3 5.161e-07 3.3 5.19e-07 3.3 5.191e-07 3.3 5.22e-07 3.3 5.221e-07 3.3 5.25e-07 3.3 5.25e-07 3.3 5.28e-07 3.3 5.28e-07 3.3 5.31e-07 3.3 5.31e-07 3.3 5.34e-07 3.3 5.34e-07 3.3 5.37e-07 3.3 5.371e-07 3.3 5.4e-07 3.3 5.401e-07 3.3 5.43e-07 3.3 5.431e-07 3.3 5.46e-07 3.3 5.461e-07 3.3 5.49e-07 3.3 5.49e-07 3.3 5.52e-07 3.3 5.52e-07 3.3 5.55e-07 3.3 5.55e-07 3.3 5.58e-07 3.3 5.58e-07 3.3 5.61e-07 3.3 5.611e-07 3.3 5.64e-07 3.3 5.641e-07 3.3 5.67e-07 3.3 5.671e-07 3.3 5.7e-07 3.3 5.701e-07 3.3 5.73e-07 3.3 5.73e-07 3.3 5.76e-07 3.3 5.76e-07 3.3 5.79e-07 3.3 5.79e-07 3.3 5.82e-07 3.3 5.821e-07 3.3 5.85e-07 3.3 5.851e-07 3.3 5.88e-07 3.3 5.881e-07 3.3 5.91e-07 3.3 5.911e-07 3.3 5.94e-07 3.3 5.94e-07 3.3 5.97e-07 3.3 5.97e-07 3.3 6e-07 3.3 6e-07 3.3 6.03e-07 3.3 6.03e-07 3.3 6.06e-07 3.3 6.061e-07 3.3 6.09e-07 3.3 6.091e-07 3.3 6.12e-07 3.3 6.121e-07 3.3 6.15e-07 3.3 6.151e-07 3.3 6.18e-07 3.3 6.18e-07 3.3 6.21e-07 3.3 6.21e-07 3.3 6.24e-07 3.3 6.24e-07 3.3 6.27e-07 3.3 6.27e-07 3.3 6.3e-07 3.3 6.301e-07 3.3 6.33e-07 3.3 6.331e-07 3.3 6.36e-07 3.3 6.361e-07 3.3 6.39e-07 3.3 6.391e-07 3.3 6.42e-07 3.3 6.42e-07 3.3 6.45e-07 3.3 6.45e-07 3.3 6.48e-07 3.3 6.48e-07 3.3 6.51e-07 3.3 6.51e-07 3.3 6.54e-07 3.3 6.541e-07 3.3 6.57e-07 3.3 6.571e-07 3.3 6.6e-07 3.3 6.601e-07 3.3 6.63e-07 3.3 6.631e-07 3.3 6.66e-07 3.3 6.66e-07 3.3 6.69e-07 3.3 6.69e-07 3.3 6.72e-07 3.3 6.72e-07 3.3 6.75e-07 3.3 6.75e-07 3.3 6.78e-07 3.3 6.781e-07 3.3 6.81e-07 3.3 6.811e-07 3.3 6.84e-07 3.3 6.841e-07 3.3 6.87e-07 3.3 6.87e-07 3.3 6.9e-07 3.3 6.9e-07 3.3 6.93e-07 3.3 6.93e-07 3.3 6.96e-07 3.3 6.96e-07 3.3 6.99e-07 3.3 6.991e-07 3.3 7.02e-07 3.3 7.021e-07 3.3 7.05e-07 3.3 7.051e-07 3.3 7.08e-07 3.3 7.081e-07 3.3 7.11e-07 3.3 7.11e-07 3.3 7.14e-07 3.3 7.14e-07 3.3 7.17e-07 3.3 7.17e-07 3.3 7.2e-07 3.3 7.2e-07 3.3 7.23e-07 3.3 7.231e-07 3.3 7.26e-07 3.3 7.261e-07 3.3 7.29e-07 3.3 7.291e-07 3.3 7.32e-07 3.3 7.321e-07 3.3 7.35e-07 3.3 7.35e-07 3.3 7.38e-07 3.3 7.38e-07 3.3 7.41e-07 3.3 7.41e-07 3.3 7.44e-07 3.3 7.44e-07 3.3 7.47e-07 3.3 7.471e-07 3.3 7.5e-07 3.3 7.501e-07 3.3 7.53e-07 3.3 7.531e-07 3.3 7.56e-07 3.3 7.561e-07 3.3 7.59e-07 3.3 7.59e-07 3.3 7.62e-07 3.3 7.62e-07 3.3 7.65e-07 3.3 7.65e-07 3.3 7.68e-07 3.3 7.68e-07 3.3 7.71e-07 3.3 7.711e-07 3.3 7.74e-07 3.3 7.741e-07 3.3 7.77e-07 3.3 7.771e-07 3.3 7.8e-07 3.3 7.8e-07 3.3 7.83e-07 3.3 7.83e-07 3.3 7.86e-07 3.3 7.86e-07 3.3 7.89e-07 3.3 7.89e-07 3.3 7.92e-07 3.3 7.921e-07 3.3 7.95e-07 3.3 7.951e-07 3.3 7.98e-07 3.3 7.981e-07 3.3 8.01e-07 3.3 8.011e-07 3.3 8.04e-07 3.3 8.04e-07 3.3 8.07e-07 3.3 8.07e-07 3.3 8.1e-07 3.3 8.1e-07 3.3 8.13e-07 3.3 8.13e-07 3.3 8.16e-07 3.3 8.161e-07 3.3 8.19e-07 3.3 8.191e-07 3.3 8.22e-07 3.3 8.221e-07 3.3 8.25e-07 3.3 8.251e-07 3.3 8.28e-07 3.3 8.28e-07 3.3 8.31e-07 3.3 8.31e-07 3.3 8.34e-07 3.3 8.34e-07 3.3 8.37e-07 3.3 8.37e-07 3.3 8.4e-07 3.3 8.401e-07 3.3 8.43e-07 3.3 8.431e-07 3.3 8.46e-07 3.3 8.461e-07 3.3 8.49e-07 3.3 8.491e-07 3.3 8.52e-07 3.3 8.52e-07 3.3 8.55e-07 3.3 8.55e-07 3.3 8.58e-07 3.3 8.58e-07 3.3 8.61e-07 3.3 8.61e-07 3.3 8.64e-07 3.3 8.641e-07 3.3 8.67e-07 3.3 8.671e-07 3.3 8.7e-07 3.3 8.701e-07 3.3 8.73e-07 3.3 8.73e-07 3.3 8.76e-07 3.3 8.76e-07 3.3 8.79e-07 3.3 8.79e-07 3.3 8.82e-07 3.3 8.82e-07 3.3 8.85e-07 3.3 8.851e-07 3.3 8.88e-07 3.3 8.881e-07 3.3 8.91e-07 3.3 8.911e-07 3.3 8.94e-07 3.3 8.941e-07 3.3 8.97e-07 3.3 8.97e-07 3.3 9e-07 3.3 9e-07 3.3 9.03e-07 3.3 9.03e-07 3.3 9.06e-07 3.3 9.06e-07 3.3 9.09e-07 3.3 9.091e-07 3.3 9.12e-07 3.3 9.121e-07 3.3 9.15e-07 3.3 9.151e-07 3.3 9.18e-07 3.3 9.181e-07 3.3 9.21e-07 3.3 9.21e-07 3.3 9.24e-07 3.3 9.24e-07 3.3 9.27e-07 3.3 9.27e-07 3.3 9.3e-07 3.3 9.3e-07 3.3 9.33e-07 3.3 9.331e-07 3.3 9.36e-07 3.3 9.361e-07 3.3 9.39e-07 3.3 9.391e-07 3.3 9.42e-07 3.3 9.421e-07 3.3 9.45e-07 3.3 9.45e-07 3.3 9.48e-07 3.3 9.48e-07 3.3 9.51e-07 3.3 9.51e-07 3.3 9.54e-07 3.3 9.54e-07 3.3 9.57e-07 3.3 9.57e-07 3.3 9.6e-07 3.3 9.6e-07 3.3 9.63e-07 3.3 9.63e-07 3.3 9.66e-07 3.3 9.66e-07 3.3 9.69e-07 3.3 9.69e-07 3.3 9.72e-07 3.3 9.72e-07 3.3 9.75e-07 3.3 9.75e-07 3.3 9.78e-07 3.3 9.78e-07 3.3 9.81e-07 3.3 9.81e-07 3.3 9.84e-07 3.3 9.84e-07 3.3 9.87e-07 3.3 9.87e-07 3.3 9.9e-07 3.3 9.9e-07 3.3 9.93e-07 3.3 9.93e-07 3.3 9.96e-07 3.3 9.96e-07 3.3 9.99e-07 3.3 9.99e-07 3.3 1.002e-06 3.3 1.002e-06 3.3 1.005e-06 3.3 1.005e-06 3.3 1.008e-06 3.3 1.008e-06 3.3 1.011e-06 3.3 1.011e-06 3.3 1.014e-06 3.3 1.014e-06 3.3 1.017e-06 3.3 1.017e-06 3.3 1.02e-06 3.3 1.02e-06 3.3 1.023e-06 3.3 1.023e-06 3.3 1.026e-06 3.3 1.026e-06 3.3 1.029e-06 3.3 1.029e-06 3.3 1.032e-06 3.3 1.032e-06 3.3 1.035e-06 3.3 1.035e-06 3.3 1.038e-06 3.3 1.038e-06 3.3 1.041e-06 3.3 1.041e-06 3.3 1.044e-06 3.3 1.044e-06 3.3 1.047e-06 3.3 1.047e-06 3.3 1.05e-06 3.3 1.05e-06 3.3 1.053e-06 3.3 1.053e-06 3.3 1.056e-06 3.3 1.056e-06 3.3 1.059e-06 3.3 1.059e-06 3.3 1.062e-06 3.3 1.062e-06 3.3 1.065e-06 3.3 1.065e-06 3.3 1.068e-06 3.3 1.068e-06 3.3 1.071e-06 3.3 1.071e-06 3.3 1.074e-06 3.3 1.074e-06 3.3 1.077e-06 3.3 1.077e-06 3.3 1.08e-06 3.3 1.08e-06 3.3 1.083e-06 3.3 1.083e-06 3.3 1.086e-06 3.3 1.086e-06 3.3 1.089e-06 3.3 1.089e-06 3.3 1.092e-06 3.3 1.092e-06 3.3 1.095e-06 3.3 1.095e-06 3.3 1.098e-06 3.3 1.098e-06 3.3 1.101e-06 3.3 1.101e-06 3.3 1.104e-06 3.3 1.104e-06 3.3 1.107e-06 3.3 1.107e-06 3.3 1.11e-06 3.3 1.11e-06 3.3 1.113e-06 3.3 1.113e-06 3.3 1.116e-06 3.3 1.116e-06 3.3 1.119e-06 3.3 1.119e-06 3.3 1.122e-06 3.3 1.122e-06 3.3 1.125e-06 3.3 1.125e-06 3.3 1.128e-06 3.3 1.128e-06 3.3 1.131e-06 3.3 1.131e-06 3.3 1.134e-06 3.3 1.134e-06 3.3 1.137e-06 3.3 1.137e-06 3.3 1.14e-06 3.3 1.14e-06 3.3 1.143e-06 3.3 1.143e-06 3.3 1.146e-06 3.3 1.146e-06 3.3 1.149e-06 3.3 1.149e-06 3.3 1.152e-06 3.3 1.152e-06 0 1.155e-06 0 1.155e-06 0 1.158e-06 0 1.158e-06 0 1.161e-06 0 1.161e-06 0 1.164e-06 0 1.164e-06 0 1.167e-06 0 1.167e-06 0 1.17e-06 0 1.17e-06 0 1.173e-06 0 1.173e-06 0 1.176e-06 0 1.176e-06 0 1.179e-06 0 1.179e-06 0 1.182e-06 0 1.182e-06 0 1.185e-06 0 1.185e-06 0 1.188e-06 0 1.188e-06 0 1.191e-06 0 1.191e-06 0 1.194e-06 0 1.194e-06 0 1.197e-06 0 1.197e-06 0 1.2e-06 0 1.2e-06 0 1.203e-06 0 1.203e-06 0 1.206e-06 0 1.206e-06 0 1.209e-06 0 1.209e-06 0 1.212e-06 0 1.212e-06 0 1.215e-06 0 1.215e-06 0 1.218e-06 0 1.218e-06 0 1.221e-06 0 1.221e-06 0 1.224e-06 0 1.224e-06 0 1.227e-06 0 1.227e-06 0 1.23e-06 0 1.23e-06 0 1.233e-06 0 1.233e-06 0 1.236e-06 0 1.236e-06 0 1.239e-06 0 1.239e-06 0 1.242e-06 0 1.242e-06 0 1.245e-06 0 1.245e-06 0 1.248e-06 0 1.248e-06 0 1.251e-06 0 1.251e-06 0 1.254e-06 0 1.254e-06 0 1.257e-06 0 1.257e-06 0 1.26e-06 0 1.26e-06 0 1.263e-06 0 1.263e-06 0 1.266e-06 0 1.266e-06 0 1.269e-06 0 1.269e-06 0 1.272e-06 0 1.272e-06 0 1.275e-06 0 1.275e-06 0 1.278e-06 0 1.278e-06 0 1.281e-06 0 1.281e-06 0 1.284e-06 0 1.284e-06 0 1.287e-06 0 1.287e-06 0 1.29e-06 0 1.29e-06 0 1.293e-06 0 1.293e-06 0 1.296e-06 0 1.296e-06 0 1.299e-06 0 1.299e-06 0 1.302e-06 0 1.302e-06 0 1.305e-06 0 1.305e-06 0 1.308e-06 0 1.308e-06 0 1.311e-06 0 1.311e-06 0 1.314e-06 0 1.314e-06 0 1.317e-06 0 1.317e-06 0 1.32e-06 0 1.32e-06 0 1.323e-06 0 1.323e-06 0 1.326e-06 0 1.326e-06 0 1.329e-06 0 1.329e-06 0 1.332e-06 0 1.332e-06 0 1.335e-06 0 1.335e-06 0 1.338e-06 0 1.338e-06 0 1.341e-06 0 1.341e-06 0 1.344e-06 0 1.344e-06 0 1.347e-06 0 1.347e-06 0 1.35e-06 0 1.35e-06 0 1.353e-06 0 1.353e-06 0 1.356e-06 0 1.356e-06 0 1.359e-06 0 1.359e-06 0 1.362e-06 0 1.362e-06 0 1.365e-06 0 1.365e-06 0 1.368e-06 0 1.368e-06 0 1.371e-06 0 1.371e-06 0 1.374e-06 0 1.374e-06 0 1.377e-06 0 1.377e-06 0 1.38e-06 0 1.38e-06 0 1.383e-06 0 1.383e-06 0 1.386e-06 0 1.386e-06 0 1.389e-06 0 1.389e-06 0 1.392e-06 0 1.392e-06 0 1.395e-06 0 1.395e-06 0 1.398e-06 0 1.398e-06 0 1.401e-06 0 1.401e-06 0 1.404e-06 0 1.404e-06 0 1.407e-06 0 1.407e-06 0 1.41e-06 0 1.41e-06 0 1.413e-06 0 1.413e-06 0 1.416e-06 0 1.416e-06 0 1.419e-06 0 1.419e-06 0 1.422e-06 0 1.422e-06 0 1.425e-06 0 1.425e-06 0 1.428e-06 0 1.428e-06 0 1.431e-06 0 1.431e-06 0 1.434e-06 0 1.434e-06 0 1.437e-06 0 1.437e-06 0 1.44e-06 0 1.44e-06 0 1.443e-06 0 1.443e-06 0 1.446e-06 0 1.446e-06 0 1.449e-06 0 1.449e-06 0 1.452e-06 0 1.452e-06 0 1.455e-06 0 1.455e-06 0 1.458e-06 0 1.458e-06 0 1.461e-06 0 1.461e-06 0 1.464e-06 0 1.464e-06 0 1.467e-06 0 1.467e-06 0 1.47e-06 0 1.47e-06 0 1.473e-06 0 1.473e-06 0 1.476e-06 0 1.476e-06 0 1.479e-06 0 1.479e-06 0 1.482e-06 0 1.482e-06 0 1.485e-06 0 1.485e-06 0 1.488e-06 0 1.488e-06 0 1.491e-06 0 1.491e-06 0 1.494e-06 0 1.494e-06 0 1.497e-06 0 1.497e-06 0 1.5e-06 0 1.5e-06 0 1.503e-06 0 1.503e-06 0 1.506e-06 0 1.506e-06 0 1.509e-06 0 1.509e-06 0 1.512e-06 0 1.512e-06 0 1.515e-06 0 1.515e-06 0 1.518e-06 0 1.518e-06 0 1.521e-06 0 1.521e-06 0 1.524e-06 0 1.524e-06 0 1.527e-06 0 1.527e-06 0 1.53e-06 0 1.53e-06 0 1.533e-06 0 1.533e-06 0)
VCin Cin 0 PWL(0 0 3e-09 0 3.05e-09 0 6e-09 0 6.05e-09 0 9e-09 0 9.05e-09 0 1.2e-08 0 1.205e-08 0 1.5e-08 0 1.505e-08 0 1.8e-08 0 1.805e-08 0 2.1e-08 0 2.105e-08 0 2.4e-08 0 2.405e-08 0 2.7e-08 0 2.705e-08 0 3e-08 0 3.005e-08 0 3.3e-08 0 3.305e-08 0 3.6e-08 0 3.605e-08 0 3.9e-08 0 3.905e-08 0 4.2e-08 0 4.205e-08 0 4.5e-08 0 4.505e-08 0 4.8e-08 0 4.805e-08 0 5.1e-08 0 5.105e-08 0 5.4e-08 0 5.405e-08 0 5.7e-08 0 5.705e-08 0 6e-08 0 6.005e-08 0 6.3e-08 0 6.305e-08 0 6.6e-08 0 6.605e-08 0 6.9e-08 0 6.905e-08 0 7.2e-08 0 7.205e-08 0 7.5e-08 0 7.505e-08 0 7.8e-08 0 7.805e-08 0 8.1e-08 0 8.105e-08 0 8.4e-08 0 8.405e-08 0 8.7e-08 0 8.705e-08 0 9e-08 0 9.005e-08 0 9.3e-08 0 9.305e-08 0 9.6e-08 0 9.605e-08 0 9.9e-08 0 9.905e-08 0 1.02e-07 0 1.021e-07 0 1.05e-07 0 1.051e-07 0 1.08e-07 0 1.081e-07 0 1.11e-07 0 1.111e-07 0 1.14e-07 0 1.141e-07 0 1.17e-07 0 1.171e-07 0 1.2e-07 0 1.2e-07 0 1.23e-07 0 1.231e-07 0 1.26e-07 0 1.26e-07 0 1.29e-07 0 1.291e-07 0 1.32e-07 0 1.32e-07 0 1.35e-07 0 1.351e-07 0 1.38e-07 0 1.38e-07 0 1.41e-07 0 1.411e-07 0 1.44e-07 0 1.44e-07 0 1.47e-07 0 1.471e-07 0 1.5e-07 0 1.5e-07 0 1.53e-07 0 1.531e-07 0 1.56e-07 0 1.56e-07 0 1.59e-07 0 1.591e-07 0 1.62e-07 0 1.62e-07 0 1.65e-07 0 1.651e-07 0 1.68e-07 0 1.68e-07 0 1.71e-07 0 1.711e-07 0 1.74e-07 0 1.741e-07 0 1.77e-07 0 1.771e-07 0 1.8e-07 0 1.801e-07 0 1.83e-07 0 1.831e-07 0 1.86e-07 0 1.861e-07 0 1.89e-07 0 1.891e-07 0 1.92e-07 0 1.921e-07 0 1.95e-07 0 1.95e-07 0 1.98e-07 0 1.981e-07 0 2.01e-07 0 2.01e-07 0 2.04e-07 0 2.041e-07 0 2.07e-07 0 2.07e-07 0 2.1e-07 0 2.101e-07 0 2.13e-07 0 2.13e-07 0 2.16e-07 0 2.161e-07 0 2.19e-07 0 2.19e-07 0 2.22e-07 0 2.221e-07 0 2.25e-07 0 2.25e-07 0 2.28e-07 0 2.281e-07 0 2.31e-07 0 2.31e-07 0 2.34e-07 0 2.341e-07 0 2.37e-07 0 2.37e-07 0 2.4e-07 0 2.4e-07 0 2.43e-07 0 2.43e-07 0 2.46e-07 0 2.461e-07 0 2.49e-07 0 2.491e-07 0 2.52e-07 0 2.52e-07 0 2.55e-07 0 2.55e-07 0 2.58e-07 0 2.581e-07 0 2.61e-07 0 2.611e-07 0 2.64e-07 0 2.64e-07 0 2.67e-07 0 2.67e-07 0 2.7e-07 0 2.701e-07 0 2.73e-07 0 2.731e-07 0 2.76e-07 0 2.76e-07 0 2.79e-07 0 2.791e-07 0 2.82e-07 0 2.821e-07 0 2.85e-07 0 2.851e-07 0 2.88e-07 0 2.88e-07 0 2.91e-07 0 2.911e-07 0 2.94e-07 0 2.941e-07 0 2.97e-07 0 2.97e-07 0 3e-07 0 3e-07 0 3.03e-07 0 3.031e-07 0 3.06e-07 0 3.061e-07 0 3.09e-07 0 3.09e-07 0 3.12e-07 0 3.12e-07 0 3.15e-07 0 3.151e-07 0 3.18e-07 0 3.181e-07 0 3.21e-07 0 3.21e-07 0 3.24e-07 0 3.24e-07 0 3.27e-07 0 3.271e-07 0 3.3e-07 0 3.301e-07 0 3.33e-07 0 3.33e-07 0 3.36e-07 0 3.36e-07 0 3.39e-07 0 3.391e-07 0 3.42e-07 0 3.421e-07 0 3.45e-07 0 3.45e-07 0 3.48e-07 0 3.48e-07 0 3.51e-07 0 3.511e-07 0 3.54e-07 0 3.541e-07 0 3.57e-07 0 3.57e-07 0 3.6e-07 0 3.6e-07 0 3.63e-07 0 3.631e-07 0 3.66e-07 0 3.661e-07 0 3.69e-07 0 3.69e-07 0 3.72e-07 0 3.72e-07 0 3.75e-07 0 3.751e-07 0 3.78e-07 0 3.781e-07 0 3.81e-07 0 3.81e-07 0 3.84e-07 0 3.841e-07 0 3.87e-07 0 3.871e-07 0 3.9e-07 0 3.9e-07 0 3.93e-07 0 3.93e-07 0 3.96e-07 0 3.961e-07 0 3.99e-07 0 3.991e-07 0 4.02e-07 0 4.02e-07 0 4.05e-07 0 4.05e-07 0 4.08e-07 0 4.081e-07 0 4.11e-07 0 4.111e-07 0 4.14e-07 0 4.14e-07 0 4.17e-07 0 4.17e-07 0 4.2e-07 0 4.201e-07 0 4.23e-07 0 4.231e-07 0 4.26e-07 0 4.26e-07 0 4.29e-07 0 4.29e-07 0 4.32e-07 0 4.321e-07 0 4.35e-07 0 4.351e-07 0 4.38e-07 0 4.38e-07 0 4.41e-07 0 4.41e-07 0 4.44e-07 0 4.441e-07 0 4.47e-07 0 4.471e-07 0 4.5e-07 0 4.5e-07 0 4.53e-07 0 4.53e-07 0 4.56e-07 0 4.561e-07 0 4.59e-07 0 4.591e-07 0 4.62e-07 0 4.62e-07 0 4.65e-07 0 4.65e-07 0 4.68e-07 0 4.681e-07 0 4.71e-07 0 4.711e-07 0 4.74e-07 0 4.74e-07 0 4.77e-07 0 4.771e-07 0 4.8e-07 0 4.8e-07 0 4.83e-07 0 4.83e-07 0 4.86e-07 0 4.86e-07 0 4.89e-07 0 4.891e-07 0 4.92e-07 0 4.921e-07 0 4.95e-07 0 4.951e-07 0 4.98e-07 0 4.981e-07 0 5.01e-07 0 5.01e-07 0 5.04e-07 0 5.04e-07 0 5.07e-07 0 5.07e-07 0 5.1e-07 0 5.1e-07 0 5.13e-07 0 5.131e-07 0 5.16e-07 0 5.161e-07 0 5.19e-07 0 5.191e-07 0 5.22e-07 0 5.221e-07 0 5.25e-07 0 5.25e-07 0 5.28e-07 0 5.28e-07 0 5.31e-07 0 5.31e-07 0 5.34e-07 0 5.34e-07 0 5.37e-07 0 5.371e-07 0 5.4e-07 0 5.401e-07 0 5.43e-07 0 5.431e-07 0 5.46e-07 0 5.461e-07 0 5.49e-07 0 5.49e-07 0 5.52e-07 0 5.52e-07 0 5.55e-07 0 5.55e-07 0 5.58e-07 0 5.58e-07 0 5.61e-07 0 5.611e-07 0 5.64e-07 0 5.641e-07 0 5.67e-07 0 5.671e-07 0 5.7e-07 0 5.701e-07 0 5.73e-07 0 5.73e-07 0 5.76e-07 0 5.76e-07 0 5.79e-07 0 5.79e-07 0 5.82e-07 0 5.821e-07 0 5.85e-07 0 5.851e-07 0 5.88e-07 0 5.881e-07 0 5.91e-07 0 5.911e-07 0 5.94e-07 0 5.94e-07 0 5.97e-07 0 5.97e-07 0 6e-07 0 6e-07 0 6.03e-07 0 6.03e-07 0 6.06e-07 0 6.061e-07 0 6.09e-07 0 6.091e-07 0 6.12e-07 0 6.121e-07 0 6.15e-07 0 6.151e-07 0 6.18e-07 0 6.18e-07 0 6.21e-07 0 6.21e-07 0 6.24e-07 0 6.24e-07 0 6.27e-07 0 6.27e-07 0 6.3e-07 0 6.301e-07 0 6.33e-07 0 6.331e-07 0 6.36e-07 0 6.361e-07 0 6.39e-07 0 6.391e-07 0 6.42e-07 0 6.42e-07 0 6.45e-07 0 6.45e-07 0 6.48e-07 0 6.48e-07 0 6.51e-07 0 6.51e-07 0 6.54e-07 0 6.541e-07 0 6.57e-07 0 6.571e-07 0 6.6e-07 0 6.601e-07 0 6.63e-07 0 6.631e-07 0 6.66e-07 0 6.66e-07 0 6.69e-07 0 6.69e-07 0 6.72e-07 0 6.72e-07 0 6.75e-07 0 6.75e-07 0 6.78e-07 0 6.781e-07 0 6.81e-07 0 6.811e-07 0 6.84e-07 0 6.841e-07 0 6.87e-07 0 6.87e-07 0 6.9e-07 0 6.9e-07 0 6.93e-07 0 6.93e-07 0 6.96e-07 0 6.96e-07 0 6.99e-07 0 6.991e-07 0 7.02e-07 0 7.021e-07 0 7.05e-07 0 7.051e-07 0 7.08e-07 0 7.081e-07 0 7.11e-07 0 7.11e-07 0 7.14e-07 0 7.14e-07 0 7.17e-07 0 7.17e-07 0 7.2e-07 0 7.2e-07 0 7.23e-07 0 7.231e-07 0 7.26e-07 0 7.261e-07 0 7.29e-07 0 7.291e-07 0 7.32e-07 0 7.321e-07 0 7.35e-07 0 7.35e-07 0 7.38e-07 0 7.38e-07 0 7.41e-07 0 7.41e-07 0 7.44e-07 0 7.44e-07 0 7.47e-07 0 7.471e-07 0 7.5e-07 0 7.501e-07 0 7.53e-07 0 7.531e-07 0 7.56e-07 0 7.561e-07 0 7.59e-07 0 7.59e-07 0 7.62e-07 0 7.62e-07 0 7.65e-07 0 7.65e-07 0 7.68e-07 0 7.68e-07 3.3 7.71e-07 3.3 7.711e-07 3.3 7.74e-07 3.3 7.741e-07 3.3 7.77e-07 3.3 7.771e-07 3.3 7.8e-07 3.3 7.8e-07 3.3 7.83e-07 3.3 7.83e-07 3.3 7.86e-07 3.3 7.86e-07 3.3 7.89e-07 3.3 7.89e-07 3.3 7.92e-07 3.3 7.921e-07 3.3 7.95e-07 3.3 7.951e-07 3.3 7.98e-07 3.3 7.981e-07 3.3 8.01e-07 3.3 8.011e-07 3.3 8.04e-07 3.3 8.04e-07 3.3 8.07e-07 3.3 8.07e-07 3.3 8.1e-07 3.3 8.1e-07 3.3 8.13e-07 3.3 8.13e-07 3.3 8.16e-07 3.3 8.161e-07 3.3 8.19e-07 3.3 8.191e-07 3.3 8.22e-07 3.3 8.221e-07 3.3 8.25e-07 3.3 8.251e-07 3.3 8.28e-07 3.3 8.28e-07 3.3 8.31e-07 3.3 8.31e-07 3.3 8.34e-07 3.3 8.34e-07 3.3 8.37e-07 3.3 8.37e-07 3.3 8.4e-07 3.3 8.401e-07 3.3 8.43e-07 3.3 8.431e-07 3.3 8.46e-07 3.3 8.461e-07 3.3 8.49e-07 3.3 8.491e-07 3.3 8.52e-07 3.3 8.52e-07 3.3 8.55e-07 3.3 8.55e-07 3.3 8.58e-07 3.3 8.58e-07 3.3 8.61e-07 3.3 8.61e-07 3.3 8.64e-07 3.3 8.641e-07 3.3 8.67e-07 3.3 8.671e-07 3.3 8.7e-07 3.3 8.701e-07 3.3 8.73e-07 3.3 8.73e-07 3.3 8.76e-07 3.3 8.76e-07 3.3 8.79e-07 3.3 8.79e-07 3.3 8.82e-07 3.3 8.82e-07 3.3 8.85e-07 3.3 8.851e-07 3.3 8.88e-07 3.3 8.881e-07 3.3 8.91e-07 3.3 8.911e-07 3.3 8.94e-07 3.3 8.941e-07 3.3 8.97e-07 3.3 8.97e-07 3.3 9e-07 3.3 9e-07 3.3 9.03e-07 3.3 9.03e-07 3.3 9.06e-07 3.3 9.06e-07 3.3 9.09e-07 3.3 9.091e-07 3.3 9.12e-07 3.3 9.121e-07 3.3 9.15e-07 3.3 9.151e-07 3.3 9.18e-07 3.3 9.181e-07 3.3 9.21e-07 3.3 9.21e-07 3.3 9.24e-07 3.3 9.24e-07 3.3 9.27e-07 3.3 9.27e-07 3.3 9.3e-07 3.3 9.3e-07 3.3 9.33e-07 3.3 9.331e-07 3.3 9.36e-07 3.3 9.361e-07 3.3 9.39e-07 3.3 9.391e-07 3.3 9.42e-07 3.3 9.421e-07 3.3 9.45e-07 3.3 9.45e-07 3.3 9.48e-07 3.3 9.48e-07 3.3 9.51e-07 3.3 9.51e-07 3.3 9.54e-07 3.3 9.54e-07 3.3 9.57e-07 3.3 9.57e-07 3.3 9.6e-07 3.3 9.6e-07 3.3 9.63e-07 3.3 9.63e-07 3.3 9.66e-07 3.3 9.66e-07 3.3 9.69e-07 3.3 9.69e-07 3.3 9.72e-07 3.3 9.72e-07 3.3 9.75e-07 3.3 9.75e-07 3.3 9.78e-07 3.3 9.78e-07 3.3 9.81e-07 3.3 9.81e-07 3.3 9.84e-07 3.3 9.84e-07 3.3 9.87e-07 3.3 9.87e-07 3.3 9.9e-07 3.3 9.9e-07 3.3 9.93e-07 3.3 9.93e-07 3.3 9.96e-07 3.3 9.96e-07 3.3 9.99e-07 3.3 9.99e-07 3.3 1.002e-06 3.3 1.002e-06 3.3 1.005e-06 3.3 1.005e-06 3.3 1.008e-06 3.3 1.008e-06 3.3 1.011e-06 3.3 1.011e-06 3.3 1.014e-06 3.3 1.014e-06 3.3 1.017e-06 3.3 1.017e-06 3.3 1.02e-06 3.3 1.02e-06 3.3 1.023e-06 3.3 1.023e-06 3.3 1.026e-06 3.3 1.026e-06 3.3 1.029e-06 3.3 1.029e-06 3.3 1.032e-06 3.3 1.032e-06 3.3 1.035e-06 3.3 1.035e-06 3.3 1.038e-06 3.3 1.038e-06 3.3 1.041e-06 3.3 1.041e-06 3.3 1.044e-06 3.3 1.044e-06 3.3 1.047e-06 3.3 1.047e-06 3.3 1.05e-06 3.3 1.05e-06 3.3 1.053e-06 3.3 1.053e-06 3.3 1.056e-06 3.3 1.056e-06 3.3 1.059e-06 3.3 1.059e-06 3.3 1.062e-06 3.3 1.062e-06 3.3 1.065e-06 3.3 1.065e-06 3.3 1.068e-06 3.3 1.068e-06 3.3 1.071e-06 3.3 1.071e-06 3.3 1.074e-06 3.3 1.074e-06 3.3 1.077e-06 3.3 1.077e-06 3.3 1.08e-06 3.3 1.08e-06 3.3 1.083e-06 3.3 1.083e-06 3.3 1.086e-06 3.3 1.086e-06 3.3 1.089e-06 3.3 1.089e-06 3.3 1.092e-06 3.3 1.092e-06 3.3 1.095e-06 3.3 1.095e-06 3.3 1.098e-06 3.3 1.098e-06 3.3 1.101e-06 3.3 1.101e-06 3.3 1.104e-06 3.3 1.104e-06 3.3 1.107e-06 3.3 1.107e-06 3.3 1.11e-06 3.3 1.11e-06 3.3 1.113e-06 3.3 1.113e-06 3.3 1.116e-06 3.3 1.116e-06 3.3 1.119e-06 3.3 1.119e-06 3.3 1.122e-06 3.3 1.122e-06 3.3 1.125e-06 3.3 1.125e-06 3.3 1.128e-06 3.3 1.128e-06 3.3 1.131e-06 3.3 1.131e-06 3.3 1.134e-06 3.3 1.134e-06 3.3 1.137e-06 3.3 1.137e-06 3.3 1.14e-06 3.3 1.14e-06 3.3 1.143e-06 3.3 1.143e-06 3.3 1.146e-06 3.3 1.146e-06 3.3 1.149e-06 3.3 1.149e-06 3.3 1.152e-06 3.3 1.152e-06 3.3 1.155e-06 3.3 1.155e-06 3.3 1.158e-06 3.3 1.158e-06 3.3 1.161e-06 3.3 1.161e-06 3.3 1.164e-06 3.3 1.164e-06 3.3 1.167e-06 3.3 1.167e-06 3.3 1.17e-06 3.3 1.17e-06 3.3 1.173e-06 3.3 1.173e-06 3.3 1.176e-06 3.3 1.176e-06 3.3 1.179e-06 3.3 1.179e-06 3.3 1.182e-06 3.3 1.182e-06 3.3 1.185e-06 3.3 1.185e-06 3.3 1.188e-06 3.3 1.188e-06 3.3 1.191e-06 3.3 1.191e-06 3.3 1.194e-06 3.3 1.194e-06 3.3 1.197e-06 3.3 1.197e-06 3.3 1.2e-06 3.3 1.2e-06 3.3 1.203e-06 3.3 1.203e-06 3.3 1.206e-06 3.3 1.206e-06 3.3 1.209e-06 3.3 1.209e-06 3.3 1.212e-06 3.3 1.212e-06 3.3 1.215e-06 3.3 1.215e-06 3.3 1.218e-06 3.3 1.218e-06 3.3 1.221e-06 3.3 1.221e-06 3.3 1.224e-06 3.3 1.224e-06 3.3 1.227e-06 3.3 1.227e-06 3.3 1.23e-06 3.3 1.23e-06 3.3 1.233e-06 3.3 1.233e-06 3.3 1.236e-06 3.3 1.236e-06 3.3 1.239e-06 3.3 1.239e-06 3.3 1.242e-06 3.3 1.242e-06 3.3 1.245e-06 3.3 1.245e-06 3.3 1.248e-06 3.3 1.248e-06 3.3 1.251e-06 3.3 1.251e-06 3.3 1.254e-06 3.3 1.254e-06 3.3 1.257e-06 3.3 1.257e-06 3.3 1.26e-06 3.3 1.26e-06 3.3 1.263e-06 3.3 1.263e-06 3.3 1.266e-06 3.3 1.266e-06 3.3 1.269e-06 3.3 1.269e-06 3.3 1.272e-06 3.3 1.272e-06 3.3 1.275e-06 3.3 1.275e-06 3.3 1.278e-06 3.3 1.278e-06 3.3 1.281e-06 3.3 1.281e-06 3.3 1.284e-06 3.3 1.284e-06 3.3 1.287e-06 3.3 1.287e-06 3.3 1.29e-06 3.3 1.29e-06 3.3 1.293e-06 3.3 1.293e-06 3.3 1.296e-06 3.3 1.296e-06 3.3 1.299e-06 3.3 1.299e-06 3.3 1.302e-06 3.3 1.302e-06 3.3 1.305e-06 3.3 1.305e-06 3.3 1.308e-06 3.3 1.308e-06 3.3 1.311e-06 3.3 1.311e-06 3.3 1.314e-06 3.3 1.314e-06 3.3 1.317e-06 3.3 1.317e-06 3.3 1.32e-06 3.3 1.32e-06 3.3 1.323e-06 3.3 1.323e-06 3.3 1.326e-06 3.3 1.326e-06 3.3 1.329e-06 3.3 1.329e-06 3.3 1.332e-06 3.3 1.332e-06 3.3 1.335e-06 3.3 1.335e-06 3.3 1.338e-06 3.3 1.338e-06 3.3 1.341e-06 3.3 1.341e-06 3.3 1.344e-06 3.3 1.344e-06 3.3 1.347e-06 3.3 1.347e-06 3.3 1.35e-06 3.3 1.35e-06 3.3 1.353e-06 3.3 1.353e-06 3.3 1.356e-06 3.3 1.356e-06 3.3 1.359e-06 3.3 1.359e-06 3.3 1.362e-06 3.3 1.362e-06 3.3 1.365e-06 3.3 1.365e-06 3.3 1.368e-06 3.3 1.368e-06 3.3 1.371e-06 3.3 1.371e-06 3.3 1.374e-06 3.3 1.374e-06 3.3 1.377e-06 3.3 1.377e-06 3.3 1.38e-06 3.3 1.38e-06 3.3 1.383e-06 3.3 1.383e-06 3.3 1.386e-06 3.3 1.386e-06 3.3 1.389e-06 3.3 1.389e-06 3.3 1.392e-06 3.3 1.392e-06 3.3 1.395e-06 3.3 1.395e-06 3.3 1.398e-06 3.3 1.398e-06 3.3 1.401e-06 3.3 1.401e-06 3.3 1.404e-06 3.3 1.404e-06 3.3 1.407e-06 3.3 1.407e-06 3.3 1.41e-06 3.3 1.41e-06 3.3 1.413e-06 3.3 1.413e-06 3.3 1.416e-06 3.3 1.416e-06 3.3 1.419e-06 3.3 1.419e-06 3.3 1.422e-06 3.3 1.422e-06 3.3 1.425e-06 3.3 1.425e-06 3.3 1.428e-06 3.3 1.428e-06 3.3 1.431e-06 3.3 1.431e-06 3.3 1.434e-06 3.3 1.434e-06 3.3 1.437e-06 3.3 1.437e-06 3.3 1.44e-06 3.3 1.44e-06 3.3 1.443e-06 3.3 1.443e-06 3.3 1.446e-06 3.3 1.446e-06 3.3 1.449e-06 3.3 1.449e-06 3.3 1.452e-06 3.3 1.452e-06 3.3 1.455e-06 3.3 1.455e-06 3.3 1.458e-06 3.3 1.458e-06 3.3 1.461e-06 3.3 1.461e-06 3.3 1.464e-06 3.3 1.464e-06 3.3 1.467e-06 3.3 1.467e-06 3.3 1.47e-06 3.3 1.47e-06 3.3 1.473e-06 3.3 1.473e-06 3.3 1.476e-06 3.3 1.476e-06 3.3 1.479e-06 3.3 1.479e-06 3.3 1.482e-06 3.3 1.482e-06 3.3 1.485e-06 3.3 1.485e-06 3.3 1.488e-06 3.3 1.488e-06 3.3 1.491e-06 3.3 1.491e-06 3.3 1.494e-06 3.3 1.494e-06 3.3 1.497e-06 3.3 1.497e-06 3.3 1.5e-06 3.3 1.5e-06 3.3 1.503e-06 3.3 1.503e-06 3.3 1.506e-06 3.3 1.506e-06 3.3 1.509e-06 3.3 1.509e-06 3.3 1.512e-06 3.3 1.512e-06 3.3 1.515e-06 3.3 1.515e-06 3.3 1.518e-06 3.3 1.518e-06 3.3 1.521e-06 3.3 1.521e-06 3.3 1.524e-06 3.3 1.524e-06 3.3 1.527e-06 3.3 1.527e-06 3.3 1.53e-06 3.3 1.53e-06 3.3 1.533e-06 3.3 1.533e-06 3.3)
CS0 S0 0 1e-14
CS1 S1 0 1e-14
CS2 S2 0 1e-14
CS3 S3 0 1e-14
CCout Cout 0 1e-14
.option method=gear
.control
tran 5p 1.536e-06
wrdata /home/ellis/EG-LOGIC/examples/adder4/gf180mcuD/ADD4_sim.dat v(S0) v(S1) v(S2) v(S3) v(Cout)
quit
.endc
.end
