* ALU181 test (sky130A)
.lib /home/ellis/pdk/sky130A/libs.tech/ngspice/sky130.lib.spice tt

* NGSPICE file created from ALU181.ext - technology: sky130A

.subckt AND A B Y VDD VSS a_329_n201# a_242_n201#
X0 Y a_242_n201# VSS VSS sky130_fd_pr__nfet_01v8 ad=0.3185 pd=2.28 as=0.3185 ps=2.28 w=0.65 l=0.15
X1 a_242_n201# B VDD VDD sky130_fd_pr__pfet_01v8 ad=0.285 pd=2.57 as=0.14 ps=1.28 w=1 l=0.15
X2 Y a_242_n201# VDD VDD sky130_fd_pr__pfet_01v8 ad=0.49 pd=2.98 as=0.49 ps=2.98 w=1 l=0.15
X3 a_329_n201# A a_242_n201# VSS sky130_fd_pr__nfet_01v8 ad=0.091 pd=0.93 as=0.18525 ps=1.87 w=0.65 l=0.15
X4 VDD A a_242_n201# VDD sky130_fd_pr__pfet_01v8 ad=0.14 pd=1.28 as=0.285 ps=2.57 w=1 l=0.15
X5 VSS B a_329_n201# VSS sky130_fd_pr__nfet_01v8 ad=0.18525 pd=1.87 as=0.091 ps=0.93 w=0.65 l=0.15
C0 a_242_n201# a_329_n201# 0.00891f
C1 a_242_n201# VDD 0.46374f
C2 a_242_n201# A 0.04393f
C3 a_242_n201# B 0.05604f
C4 a_242_n201# Y 0.05622f
C5 a_329_n201# VDD 0
C6 VDD A 0.38371f
C7 VDD B 0.07775f
C8 VDD Y 0.26158f
C9 A B 0.08477f
C10 A Y 0
C11 B Y 0
C12 Y VSS 0.4237f
C13 B VSS 0.81961f
C14 A VSS 0.40204f
C15 VDD VSS 3.0499f
C16 a_329_n201# VSS 0.01072f
C17 a_242_n201# VSS 0.26506f
.ends

.subckt NAND A B Y VDD VSS a_371_n201#
X0 Y B VDD VDD sky130_fd_pr__pfet_01v8 ad=0.285 pd=2.57 as=0.14 ps=1.28 w=1 l=0.15
X1 VSS B a_371_n201# VSS sky130_fd_pr__nfet_01v8 ad=0.18525 pd=1.87 as=0.091 ps=0.93 w=0.65 l=0.15
X2 VDD A Y VDD sky130_fd_pr__pfet_01v8 ad=0.14 pd=1.28 as=0.285 ps=2.57 w=1 l=0.15
X3 a_371_n201# A Y VSS sky130_fd_pr__nfet_01v8 ad=0.091 pd=0.93 as=0.18525 ps=1.87 w=0.65 l=0.15
C0 a_371_n201# VDD 0
C1 a_371_n201# Y 0.00891f
C2 VDD A 0.40978f
C3 VDD B 0.0838f
C4 VDD Y 0.57624f
C5 A B 0.08574f
C6 A Y 0.04397f
C7 B Y 0.04134f
C8 Y VSS 1.25473f
C9 B VSS 0.85635f
C10 A VSS 0.40447f
C11 VDD VSS 3.0692f
C12 a_371_n201# VSS 0.01051f
.ends

.subckt NOT A Y VDD VSS
X0 Y A VDD VDD sky130_fd_pr__pfet_01v8 ad=0.285 pd=2.57 as=0.285 ps=2.57 w=1 l=0.15
X1 Y A VSS VSS sky130_fd_pr__nfet_01v8 ad=0.18525 pd=1.87 as=0.18525 ps=1.87 w=0.65 l=0.15
C0 VDD A 0.20594f
C1 VDD Y 0.43474f
C2 A Y 0.03678f
C3 Y VSS 1.3583f
C4 A VSS 0.54489f
C5 VDD VSS 2.77918f
.ends

.subckt OR A B Y VDD VSS a_407_n201# a_494_80#
X0 Y a_407_n201# VDD VDD sky130_fd_pr__pfet_01v8 ad=0.49 pd=2.98 as=0.49 ps=2.98 w=1 l=0.15
X1 VSS A a_407_n201# VSS sky130_fd_pr__nfet_01v8 ad=0.091 pd=0.93 as=0.18525 ps=1.87 w=0.65 l=0.15
X2 a_407_n201# B VSS VSS sky130_fd_pr__nfet_01v8 ad=0.18525 pd=1.87 as=0.091 ps=0.93 w=0.65 l=0.15
X3 VDD B a_494_80# VDD sky130_fd_pr__pfet_01v8 ad=0.285 pd=2.57 as=0.14 ps=1.28 w=1 l=0.15
X4 Y a_407_n201# VSS VSS sky130_fd_pr__nfet_01v8 ad=0.3185 pd=2.28 as=0.3185 ps=2.28 w=0.65 l=0.15
X5 a_494_80# A a_407_n201# VDD sky130_fd_pr__pfet_01v8 ad=0.14 pd=1.28 as=0.285 ps=2.57 w=1 l=0.15
C0 a_407_n201# a_494_80# 0.01259f
C1 a_407_n201# VDD 0.29532f
C2 a_407_n201# A 0.04371f
C3 a_407_n201# B 0.05381f
C4 a_407_n201# Y 0.05582f
C5 a_494_80# VDD 0.01661f
C6 VDD A 0.39741f
C7 VDD B 0.07601f
C8 VDD Y 0.29718f
C9 A B 0.08856f
C10 A Y 0
C11 B Y 0
C12 Y VSS 0.48496f
C13 B VSS 0.93218f
C14 A VSS 0.48762f
C15 VDD VSS 3.44497f
C16 a_494_80# VSS 0
C17 a_407_n201# VSS 0.38357f
.ends

.subckt XOR A B Y VDD VSS li_n59_n770# a_1115_n285# a_1028_164# m1_n59_n770# a_831_164#
+ a_744_n285#
X0 a_1028_164# B VDD VDD sky130_fd_pr__pfet_01v8 ad=0.2425 pd=1.485 as=0.14 ps=1.28 w=1 l=0.15
X1 Y a_744_n285# VSS VSS sky130_fd_pr__nfet_01v8 ad=0.3185 pd=2.28 as=0.15763 ps=1.135 w=0.65 l=0.15
X2 Y a_744_n285# a_1028_164# VDD sky130_fd_pr__pfet_01v8 ad=0.49 pd=2.98 as=0.2425 ps=1.485 w=1 l=0.15
X3 a_831_164# A a_744_n285# VDD sky130_fd_pr__pfet_01v8 ad=0.14 pd=1.28 as=0.285 ps=2.57 w=1 l=0.15
X4 VDD B a_831_164# VDD sky130_fd_pr__pfet_01v8 ad=0.285 pd=2.57 as=0.14 ps=1.28 w=1 l=0.15
X5 VSS A a_744_n285# VSS sky130_fd_pr__nfet_01v8 ad=0.091 pd=0.93 as=0.18525 ps=1.87 w=0.65 l=0.15
X6 VDD A a_1028_164# VDD sky130_fd_pr__pfet_01v8 ad=0.14 pd=1.28 as=0.285 ps=2.57 w=1 l=0.15
X7 a_744_n285# B VSS VSS sky130_fd_pr__nfet_01v8 ad=0.18525 pd=1.87 as=0.091 ps=0.93 w=0.65 l=0.15
X8 a_1115_n285# A Y VSS sky130_fd_pr__nfet_01v8 ad=0.091 pd=0.93 as=0.18525 ps=1.87 w=0.65 l=0.15
X9 VSS B a_1115_n285# VSS sky130_fd_pr__nfet_01v8 ad=0.15763 pd=1.135 as=0.091 ps=0.93 w=0.65 l=0.15
C0 a_744_n285# a_831_164# 0.01081f
C1 a_744_n285# a_1028_164# 0.09179f
C2 a_744_n285# li_n59_n770# 0.0058f
C3 a_744_n285# m1_n59_n770# 0
C4 a_744_n285# VDD 0.34024f
C5 a_744_n285# A 0.0725f
C6 a_744_n285# B 0.12453f
C7 a_744_n285# Y 0.2337f
C8 a_831_164# VDD 0.0156f
C9 a_1028_164# VDD 0.28588f
C10 a_1028_164# A 0.03166f
C11 a_1028_164# B 0.03043f
C12 a_1028_164# Y 0.05886f
C13 a_1115_n285# VDD 0
C14 a_1115_n285# Y 0.00891f
C15 li_n59_n770# m1_n59_n770# 0.64924f
C16 li_n59_n770# VDD 0.08118f
C17 li_n59_n770# A 0.06415f
C18 li_n59_n770# B 0.06302f
C19 m1_n59_n770# VDD 0.12266f
C20 m1_n59_n770# A 0.01731f
C21 m1_n59_n770# B 0.01723f
C22 m1_n59_n770# Y 0
C23 VDD A 0.72297f
C24 VDD B 0.18583f
C25 VDD Y 0.29473f
C26 A B 0.2998f
C27 A Y 0.02289f
C28 B Y 0.0227f
C29 Y VSS 0.62914f
C30 B VSS 1.53202f
C31 A VSS 0.87509f
C32 VDD VSS 4.34098f
C33 m1_n59_n770# VSS 0.71489f
C34 li_n59_n770# VSS 0.91068f
C35 a_1115_n285# VSS 0.00905f
C36 a_1028_164# VSS 0.00166f
C37 a_831_164# VSS 0
C38 a_744_n285# VSS 0.39213f
.ends

.subckt NOR A B Y VDD VSS a_490_80#
X0 a_490_80# A Y VDD sky130_fd_pr__pfet_01v8 ad=0.14 pd=1.28 as=0.285 ps=2.57 w=1 l=0.15
X1 VDD B a_490_80# VDD sky130_fd_pr__pfet_01v8 ad=0.285 pd=2.57 as=0.14 ps=1.28 w=1 l=0.15
X2 Y B VSS VSS sky130_fd_pr__nfet_01v8 ad=0.18525 pd=1.87 as=0.091 ps=0.93 w=0.65 l=0.15
X3 VSS A Y VSS sky130_fd_pr__nfet_01v8 ad=0.091 pd=0.93 as=0.18525 ps=1.87 w=0.65 l=0.15
C0 a_490_80# VDD 0.01738f
C1 a_490_80# Y 0.01259f
C2 VDD A 0.40312f
C3 VDD B 0.0828f
C4 VDD Y 0.43977f
C5 A B 0.08847f
C6 A Y 0.04372f
C7 B Y 0.03905f
C8 Y VSS 1.40654f
C9 B VSS 0.94131f
C10 A VSS 0.4841f
C11 VDD VSS 3.20928f
C12 a_490_80# VSS 0
.ends

.subckt ALU181 A0 A1 A2 A3 B0 B1 B2 B3 S0 S1 S2 S3 M Cn F0 F1 F2 F3 AEQB P_N G_N Cn4
+ VDD VSS
XAND_e23 F2 F3 AND_eq/B VDD VSS AND_e23/a_329_n201# AND_e23/a_242_n201# AND
XAND_e01 F0 F1 AND_eq/A VDD VSS AND_e01/a_329_n201# AND_e01/a_242_n201# AND
XNAND_a4_0 B0 S3 NAND_v0/B VDD VSS NAND_a4_0/a_371_n201# NAND
XNOT_nb0 B0 NOT_nb0/Y VDD VSS NOT
XNAND_a4_1 B1 S3 NAND_v1/B VDD VSS NAND_a4_1/a_371_n201# NAND
XNOT_nb1 B1 NOT_nb1/Y VDD VSS NOT
XNAND_a4_3 B3 S3 NAND_v3/B VDD VSS NAND_a4_3/a_371_n201# NAND
XNAND_a4_2 B2 S3 NAND_v2/B VDD VSS NAND_a4_2/a_371_n201# NAND
XNOT_nb2 B2 NOT_nb2/Y VDD VSS NOT
XOR_p0 A0 OR_p0/B OR_p0/Y VDD VSS OR_p0/a_407_n201# OR_p0/a_494_80# OR
XNOT_nb3 B3 NOT_nb3/Y VDD VSS NOT
XOR_p1 A1 OR_p1/B OR_p1/Y VDD VSS OR_p1/a_407_n201# OR_p1/a_494_80# OR
XNAND_a2_1 NOT_nb1/Y S1 NAND_u1/B VDD VSS NAND_a2_1/a_371_n201# NAND
XNAND_a2_0 NOT_nb0/Y S1 NAND_u0/B VDD VSS NAND_a2_0/a_371_n201# NAND
XOR_p3 A3 OR_p3/B OR_p3/Y VDD VSS OR_p3/a_407_n201# OR_p3/a_494_80# OR
XOR_p2 A2 OR_p2/B OR_p2/Y VDD VSS OR_p2/a_407_n201# OR_p2/a_494_80# OR
XNAND_a2_2 NOT_nb2/Y S1 NAND_u2/B VDD VSS NAND_a2_2/a_371_n201# NAND
XXOR_h0 OR_p0/Y XOR_h0/B XOR_h0/Y VDD VSS XOR_h0/li_n59_n770# XOR_h0/a_1115_n285#
+ XOR_h0/a_1028_164# XOR_h0/m1_n59_n770# XOR_h0/a_831_164# XOR_h0/a_744_n285# XOR
XNAND_a2_3 NOT_nb3/Y S1 NAND_u3/B VDD VSS NAND_a2_3/a_371_n201# NAND
XXOR_h1 OR_p1/Y XOR_h1/B XOR_h1/Y VDD VSS XOR_h1/li_n59_n770# XOR_h1/a_1115_n285#
+ XOR_h1/a_1028_164# XOR_h1/m1_n59_n770# XOR_h1/a_831_164# XOR_h1/a_744_n285# XOR
XNOT_ncout OR_cy3/Y Cn4 VDD VSS NOT
XXOR_h2 OR_p2/Y XOR_h2/B XOR_h2/Y VDD VSS XOR_h2/li_n59_n770# XOR_h2/a_1115_n285#
+ XOR_h2/a_1028_164# XOR_h2/m1_n59_n770# XOR_h2/a_831_164# XOR_h2/a_744_n285# XOR
XXOR_f0 XOR_h0/Y OR_k0/Y F0 VDD VSS XOR_f0/li_n59_n770# XOR_f0/a_1115_n285# XOR_f0/a_1028_164#
+ XOR_f0/m1_n59_n770# XOR_f0/a_831_164# XOR_f0/a_744_n285# XOR
XOR_k0 M OR_k0/B OR_k0/Y VDD VSS OR_k0/a_407_n201# OR_k0/a_494_80# OR
XXOR_h3 OR_p3/Y XOR_h3/B XOR_h3/Y VDD VSS XOR_h3/li_n59_n770# XOR_h3/a_1115_n285#
+ XOR_h3/a_1028_164# XOR_h3/m1_n59_n770# XOR_h3/a_831_164# XOR_h3/a_744_n285# XOR
XXOR_f1 XOR_h1/Y OR_k1/Y F1 VDD VSS XOR_f1/li_n59_n770# XOR_f1/a_1115_n285# XOR_f1/a_1028_164#
+ XOR_f1/m1_n59_n770# XOR_f1/a_831_164# XOR_f1/a_744_n285# XOR
XOR_k1 M OR_k1/B OR_k1/Y VDD VSS OR_k1/a_407_n201# OR_k1/a_494_80# OR
XXOR_f3 XOR_h3/Y OR_k3/Y F3 VDD VSS XOR_f3/li_n59_n770# XOR_f3/a_1115_n285# XOR_f3/a_1028_164#
+ XOR_f3/m1_n59_n770# XOR_f3/a_831_164# XOR_f3/a_744_n285# XOR
XXOR_f2 XOR_h2/Y OR_k2/Y F2 VDD VSS XOR_f2/li_n59_n770# XOR_f2/a_1115_n285# XOR_f2/a_1028_164#
+ XOR_f2/m1_n59_n770# XOR_f2/a_831_164# XOR_f2/a_744_n285# XOR
XOR_k2 M OR_k2/B OR_k2/Y VDD VSS OR_k2/a_407_n201# OR_k2/a_494_80# OR
XOR_k3 M OR_k3/B OR_k3/Y VDD VSS OR_k3/a_407_n201# OR_k3/a_494_80# OR
XNAND_pg NAND_pg/A NAND_pg/B P_N VDD VSS NAND_pg/a_371_n201# NAND
XNAND_a3_0 NOT_nb0/Y S2 NAND_v0/A VDD VSS NAND_a3_0/a_371_n201# NAND
XAND_q1 OR_p1/Y XOR_h0/B OR_gr1/B VDD VSS AND_q1/a_329_n201# AND_q1/a_242_n201# AND
XNAND_a3_1 NOT_nb1/Y S2 NAND_v1/A VDD VSS NAND_a3_1/a_371_n201# NAND
XAND_pc0 OR_p0/Y OR_k0/B OR_cy0/B VDD VSS AND_pc0/a_329_n201# AND_pc0/a_242_n201#
+ AND
XAND_q3 OR_p3/Y OR_gr2/Y NOR_gg/B VDD VSS AND_q3/a_329_n201# AND_q3/a_242_n201# AND
XAND_q2 OR_p2/Y OR_gr1/Y OR_gr2/B VDD VSS AND_q2/a_329_n201# AND_q2/a_242_n201# AND
XNAND_a3_2 NOT_nb2/Y S2 NAND_v2/A VDD VSS NAND_a3_2/a_371_n201# NAND
XAND_pc1 OR_p1/Y OR_k1/B OR_cy1/B VDD VSS AND_pc1/a_329_n201# AND_pc1/a_242_n201#
+ AND
XNAND_a3_3 NOT_nb3/Y S2 NAND_v3/A VDD VSS NAND_a3_3/a_371_n201# NAND
XAND_pc2 OR_p2/Y OR_k2/B OR_cy2/B VDD VSS AND_pc2/a_329_n201# AND_pc2/a_242_n201#
+ AND
XNAND_v1 NAND_v1/A NAND_v1/B AND_g1/B VDD VSS NAND_v1/a_371_n201# NAND
XNAND_v0 NAND_v0/A NAND_v0/B AND_g0/B VDD VSS NAND_v0/a_371_n201# NAND
XNAND_u0 NAND_u0/A NAND_u0/B OR_p0/B VDD VSS NAND_u0/a_371_n201# NAND
XNAND_a1_0 B0 S0 NAND_u0/A VDD VSS NAND_a1_0/a_371_n201# NAND
XAND_eq AND_eq/A AND_eq/B AEQB VDD VSS AND_eq/a_329_n201# AND_eq/a_242_n201# AND
XAND_pc3 OR_p3/Y OR_k3/B OR_cy3/B VDD VSS AND_pc3/a_329_n201# AND_pc3/a_242_n201#
+ AND
XNAND_v2 NAND_v2/A NAND_v2/B AND_g2/B VDD VSS NAND_v2/a_371_n201# NAND
XNAND_u1 NAND_u1/A NAND_u1/B OR_p1/B VDD VSS NAND_u1/a_371_n201# NAND
XNAND_a1_1 B1 S0 NAND_u1/A VDD VSS NAND_a1_1/a_371_n201# NAND
XNAND_v3 NAND_v3/A NAND_v3/B AND_g3/B VDD VSS NAND_v3/a_371_n201# NAND
XNAND_u2 NAND_u2/A NAND_u2/B OR_p2/B VDD VSS NAND_u2/a_371_n201# NAND
XNAND_a1_2 B2 S0 NAND_u2/A VDD VSS NAND_a1_2/a_371_n201# NAND
XNOT_ncn Cn OR_k0/B VDD VSS NOT
XAND_pp23 OR_p2/Y OR_p3/Y NAND_pg/B VDD VSS AND_pp23/a_329_n201# AND_pp23/a_242_n201#
+ AND
XAND_pp01 OR_p0/Y OR_p1/Y NAND_pg/A VDD VSS AND_pp01/a_329_n201# AND_pp01/a_242_n201#
+ AND
XNAND_u3 NAND_u3/A NAND_u3/B OR_p3/B VDD VSS NAND_u3/a_371_n201# NAND
XNAND_a1_3 B3 S0 NAND_u3/A VDD VSS NAND_a1_3/a_371_n201# NAND
XNOR_gg XOR_h3/B NOR_gg/B G_N VDD VSS NOR_gg/a_490_80# NOR
XOR_cy0 XOR_h0/B OR_cy0/B OR_k1/B VDD VSS OR_cy0/a_407_n201# OR_cy0/a_494_80# OR
XOR_gr1 XOR_h1/B OR_gr1/B OR_gr1/Y VDD VSS OR_gr1/a_407_n201# OR_gr1/a_494_80# OR
XOR_cy1 XOR_h1/B OR_cy1/B OR_k2/B VDD VSS OR_cy1/a_407_n201# OR_cy1/a_494_80# OR
XOR_gr2 XOR_h2/B OR_gr2/B OR_gr2/Y VDD VSS OR_gr2/a_407_n201# OR_gr2/a_494_80# OR
XOR_cy2 XOR_h2/B OR_cy2/B OR_k3/B VDD VSS OR_cy2/a_407_n201# OR_cy2/a_494_80# OR
XAND_g0 A0 AND_g0/B XOR_h0/B VDD VSS AND_g0/a_329_n201# AND_g0/a_242_n201# AND
XOR_cy3 XOR_h3/B OR_cy3/B OR_cy3/Y VDD VSS OR_cy3/a_407_n201# OR_cy3/a_494_80# OR
XAND_g2 A2 AND_g2/B XOR_h2/B VDD VSS AND_g2/a_329_n201# AND_g2/a_242_n201# AND
XAND_g1 A1 AND_g1/B XOR_h1/B VDD VSS AND_g1/a_329_n201# AND_g1/a_242_n201# AND
XAND_g3 A3 AND_g3/B XOR_h3/B VDD VSS AND_g3/a_329_n201# AND_g3/a_242_n201# AND
C0 AND_e23/a_242_n201# AND_eq/B 0
C1 AND_e23/a_242_n201# AND_eq/A 0.03939f
C2 AND_e23/a_242_n201# F0 0.00359f
C3 AND_e23/a_242_n201# F3 0.00204f
C4 AND_e23/a_242_n201# F2 0.00948f
C5 AND_e23/a_242_n201# VDD 0
C6 AND_e23/a_242_n201# G_N 0.01548f
C7 AND_e23/a_329_n201# AND_eq/A 0.00151f
C8 AND_e23/a_329_n201# F0 0
C9 AND_e23/a_329_n201# F2 0
C10 AND_e23/a_329_n201# G_N 0.0018f
C11 AND_eq/B AND_eq/A 0.29854f
C12 AND_eq/B F0 0.00137f
C13 AND_eq/B F3 0.09246f
C14 AND_eq/B F2 0.29399f
C15 AND_eq/B AND_eq/a_242_n201# 0.00483f
C16 AND_eq/B AND_eq/a_329_n201# 0
C17 AND_eq/B AEQB 0.00136f
C18 AND_eq/B VDD 0.01291f
C19 AND_eq/B G_N 0.27034f
C20 AND_e01/a_242_n201# AND_eq/A 0
C21 AND_e01/a_242_n201# F0 0.01305f
C22 AND_e01/a_242_n201# F1 0.00563f
C23 AND_e01/a_242_n201# F3 0
C24 AND_e01/a_242_n201# VDD 0
C25 AND_e01/a_242_n201# G_N 0.04936f
C26 AND_e01/a_329_n201# F1 0.00149f
C27 AND_e01/a_329_n201# G_N 0.00218f
C28 AND_eq/A F0 0.14367f
C29 AND_eq/A F1 0.0071f
C30 AND_eq/A F3 0.00903f
C31 AND_eq/A F2 0.74744f
C32 AND_eq/A AND_eq/a_242_n201# 0.00257f
C33 AND_eq/A AEQB 0.00103f
C34 AND_eq/A VDD 0.4318f
C35 AND_eq/A G_N 0.47591f
C36 NAND_a4_0/a_371_n201# S3 0
C37 NAND_a4_0/a_371_n201# NAND_v0/A 0
C38 NAND_a4_0/a_371_n201# AND_g0/B 0.00277f
C39 S3 NAND_v0/B 0
C40 S3 B0 0.19306f
C41 S3 NOT_nb0/Y 0.54807f
C42 S3 NAND_v1/B 0
C43 S3 B1 0.51135f
C44 S3 NOT_nb1/Y 0.58497f
C45 S3 NAND_v3/B 0
C46 S3 NAND_v2/B 0.10618f
C47 S3 B2 0.14872f
C48 S3 NOT_nb2/Y 0.17785f
C49 S3 OR_p0/a_407_n201# 0
C50 S3 A0 5.2786f
C51 S3 OR_p0/Y 0.12491f
C52 S3 B3 1.04036f
C53 S3 NOT_nb3/Y 1.12589f
C54 S3 A1 0.04821f
C55 S3 OR_p1/Y 0.07025f
C56 S3 NAND_u1/B 1.24594f
C57 S3 S1 1.39768f
C58 S3 NAND_u0/B 0.00342f
C59 S3 A3 1.14352f
C60 S3 A2 0.06f
C61 S3 OR_p2/Y 0.03917f
C62 S3 XOR_h0/a_744_n285# 0
C63 S3 XOR_h0/li_n59_n770# 0
C64 S3 XOR_h0/m1_n59_n770# 0
C65 S3 XOR_h0/Y 0.05386f
C66 S3 XOR_h1/Y 0.05608f
C67 S3 XOR_h2/a_744_n285# 0
C68 S3 XOR_h2/Y 0.07617f
C69 S3 XOR_f0/a_744_n285# 0
C70 S3 XOR_f0/li_n59_n770# 0
C71 S3 XOR_f0/m1_n59_n770# 0
C72 S3 F0 0.10979f
C73 S3 OR_k0/a_407_n201# 0
C74 S3 M 1.28388f
C75 S3 OR_k0/Y 0
C76 S3 XOR_h3/Y 0.01212f
C77 S3 F1 0.10709f
C78 S3 OR_k1/a_407_n201# 0
C79 S3 XOR_f2/li_n59_n770# 0
C80 S3 F2 0.00144f
C81 S3 OR_k2/a_407_n201# 0
C82 S3 OR_k2/Y 0
C83 S3 OR_k3/Y 0.00612f
C84 S3 NAND_a3_0/a_371_n201# 0
C85 S3 S2 1.03487f
C86 S3 NAND_v0/A 0.31532f
C87 S3 NAND_a3_1/a_371_n201# 0.00149f
C88 S3 NAND_v1/A 0.13066f
C89 S3 AND_pc0/a_242_n201# 0
C90 S3 OR_cy0/B 0
C91 S3 NAND_a3_2/a_371_n201# 0
C92 S3 NAND_v2/A 0.46714f
C93 S3 NAND_v3/A 0.01613f
C94 S3 AND_g0/B 0.7422f
C95 S3 OR_p0/B 0.00345f
C96 S3 S0 2.90888f
C97 S3 NAND_u0/A 0.00945f
C98 S3 NAND_u1/A 0.10396f
C99 S3 NAND_a1_2/a_371_n201# 0
C100 S3 NAND_u2/A 0.00761f
C101 S3 VDD 7.64927f
C102 S3 Cn 0.04406f
C103 S3 OR_k0/B 0.11884f
C104 S3 NAND_u3/A 0.00471f
C105 S3 OR_cy0/a_407_n201# 0
C106 S3 OR_k1/B 0.46058f
C107 S3 OR_k2/B 0.09265f
C108 S3 AND_g0/a_242_n201# 0
C109 S3 XOR_h0/B 0.04726f
C110 S3 XOR_h2/B 0.03411f
C111 S3 XOR_h1/B 0.37441f
C112 S3 XOR_h3/B 0
C113 NAND_v0/B B0 -0
C114 NAND_v0/B NAND_v0/A 0.06625f
C115 NAND_v0/B NAND_v0/a_371_n201# 0
C116 NAND_v0/B AND_g0/B 0.43725f
C117 NAND_v0/B VDD 0.01802f
C118 B0 NOT_nb0/Y 2.73845f
C119 B0 OR_p0/a_407_n201# 0.01112f
C120 B0 OR_p0/a_494_80# 0.00204f
C121 B0 A0 2.76366f
C122 B0 OR_p0/Y 1.89978f
C123 B0 NAND_a2_0/a_371_n201# 0
C124 B0 S1 0.11697f
C125 B0 NAND_u0/B 0.10774f
C126 B0 XOR_h0/li_n59_n770# 0
C127 B0 XOR_h0/m1_n59_n770# 0
C128 B0 XOR_f0/li_n59_n770# 0
C129 B0 XOR_f0/m1_n59_n770# 0
C130 B0 NAND_a3_0/a_371_n201# 0
C131 B0 S2 0.35688f
C132 B0 NAND_v0/A 0.19844f
C133 B0 AND_g0/B 1.62482f
C134 B0 OR_p0/B 0.04859f
C135 B0 NAND_a1_0/a_371_n201# 0
C136 B0 S0 0.2977f
C137 B0 NAND_u0/A 1.36427f
C138 B0 VDD 3.4109f
C139 B0 Cn 0.22903f
C140 B0 OR_k0/B 0.38917f
C141 NOT_nb0/Y OR_p0/a_407_n201# 0.0057f
C142 NOT_nb0/Y OR_p0/a_494_80# 0
C143 NOT_nb0/Y A0 1.25468f
C144 NOT_nb0/Y OR_p0/Y 0.06827f
C145 NOT_nb0/Y NAND_a2_0/a_371_n201# 0
C146 NOT_nb0/Y S1 0.50311f
C147 NOT_nb0/Y NAND_u0/B 0.38259f
C148 NOT_nb0/Y XOR_f0/li_n59_n770# 0
C149 NOT_nb0/Y XOR_f0/m1_n59_n770# 0
C150 NOT_nb0/Y OR_k0/Y 0.00175f
C151 NOT_nb0/Y S2 0.99069f
C152 NOT_nb0/Y AND_g0/B 2.82182f
C153 NOT_nb0/Y NAND_u0/a_371_n201# 0
C154 NOT_nb0/Y OR_p0/B 0.40854f
C155 NOT_nb0/Y S0 0.30433f
C156 NOT_nb0/Y NAND_u0/A 0.35389f
C157 NOT_nb0/Y VDD 1.13958f
C158 NOT_nb0/Y OR_k0/B 0.0082f
C159 NAND_a4_1/a_371_n201# B1 0.00283f
C160 NAND_a4_1/a_371_n201# NAND_u1/B 0
C161 NAND_a4_1/a_371_n201# S1 0
C162 NAND_a4_1/a_371_n201# F0 0
C163 NAND_a4_1/a_371_n201# M 0
C164 NAND_v1/B B1 0.43348f
C165 NAND_v1/B NOT_nb1/Y 0.00214f
C166 NAND_v1/B OR_p0/Y 0.03764f
C167 NAND_v1/B A1 0.00388f
C168 NAND_v1/B OR_p1/Y 0.00551f
C169 NAND_v1/B NAND_u1/B 0.25794f
C170 NAND_v1/B S1 0.00106f
C171 NAND_v1/B F0 0.27201f
C172 NAND_v1/B M 0.09061f
C173 NAND_v1/B F1 0.08093f
C174 NAND_v1/B NAND_v1/A 0.03501f
C175 NAND_v1/B AND_g1/B 0.00216f
C176 NAND_v1/B NAND_u1/A 0
C177 NAND_v1/B VDD 0.02571f
C178 NAND_v1/B XOR_h0/B 0
C179 B1 NOT_nb1/Y 0.4366f
C180 B1 A0 0.23661f
C181 B1 OR_p0/Y 0.06744f
C182 B1 OR_p1/a_407_n201# 0.01112f
C183 B1 OR_p1/a_494_80# 0.00204f
C184 B1 A1 0.55779f
C185 B1 OR_p1/Y 2.44656f
C186 B1 NAND_u1/B 1.03819f
C187 B1 S1 0.43063f
C188 B1 XOR_h1/a_744_n285# 0
C189 B1 XOR_h1/a_1115_n285# 0
C190 B1 XOR_h1/li_n59_n770# 0.00526f
C191 B1 XOR_h1/m1_n59_n770# 0.01018f
C192 B1 XOR_h1/Y 0
C193 B1 F0 0.25596f
C194 B1 M 1.42896f
C195 B1 F1 1.22771f
C196 B1 S2 1.3496f
C197 B1 NAND_v1/A 0.2875f
C198 B1 OR_cy0/B 0
C199 B1 NAND_v1/a_371_n201# 0.00277f
C200 B1 AND_g1/B 0.43816f
C201 B1 AND_g0/B 0
C202 B1 S0 0.12242f
C203 B1 NAND_u1/a_371_n201# 0.00116f
C204 B1 OR_p1/B 0.09741f
C205 B1 NAND_u1/A 1.81976f
C206 B1 VDD 2.94368f
C207 B1 Cn 0
C208 B1 OR_cy0/a_407_n201# 0
C209 B1 OR_cy0/a_494_80# 0
C210 B1 OR_k1/B 1.97636f
C211 B1 AND_g0/a_242_n201# 0
C212 B1 XOR_h0/B 0.06804f
C213 B1 AND_g1/a_242_n201# 0.02678f
C214 B1 AND_g1/a_329_n201# 0.00277f
C215 B1 XOR_h1/B 0.37549f
C216 NOT_nb1/Y OR_p0/Y 0.06305f
C217 NOT_nb1/Y A1 0.00644f
C218 NOT_nb1/Y OR_p1/Y 0.11477f
C219 NOT_nb1/Y NAND_u1/B 0.05125f
C220 NOT_nb1/Y S1 0.08005f
C221 NOT_nb1/Y XOR_h0/Y 0.00245f
C222 NOT_nb1/Y XOR_h1/a_744_n285# 0
C223 NOT_nb1/Y XOR_h1/li_n59_n770# 0
C224 NOT_nb1/Y XOR_h1/m1_n59_n770# 0
C225 NOT_nb1/Y XOR_h1/Y 0.0048f
C226 NOT_nb1/Y XOR_f0/a_744_n285# 0
C227 NOT_nb1/Y XOR_f0/li_n59_n770# 0
C228 NOT_nb1/Y XOR_f0/m1_n59_n770# 0
C229 NOT_nb1/Y F0 0.78802f
C230 NOT_nb1/Y OR_k0/a_407_n201# 0
C231 NOT_nb1/Y M 0.073f
C232 NOT_nb1/Y OR_k0/Y 0
C233 NOT_nb1/Y XOR_f1/li_n59_n770# 0.00142f
C234 NOT_nb1/Y XOR_f1/m1_n59_n770# 0
C235 NOT_nb1/Y F1 0
C236 NOT_nb1/Y OR_k1/Y 0
C237 NOT_nb1/Y S2 0.52775f
C238 NOT_nb1/Y NAND_v1/A 0.00117f
C239 NOT_nb1/Y AND_pc0/a_242_n201# 0
C240 NOT_nb1/Y OR_cy0/B 0
C241 NOT_nb1/Y AND_g1/B 0.00209f
C242 NOT_nb1/Y S0 0.79878f
C243 NOT_nb1/Y NAND_a1_1/a_371_n201# 0
C244 NOT_nb1/Y NAND_u1/A 0.65096f
C245 NOT_nb1/Y VDD 5.21336f
C246 NOT_nb1/Y OR_k0/B 0
C247 NOT_nb1/Y OR_cy0/a_407_n201# 0
C248 NOT_nb1/Y OR_k1/B 0.31428f
C249 NOT_nb1/Y XOR_h0/B 0.05795f
C250 NOT_nb1/Y AND_g1/a_242_n201# 0
C251 NOT_nb1/Y XOR_h1/B 0.00285f
C252 NAND_a4_3/a_371_n201# OR_p0/Y 0
C253 NAND_a4_3/a_371_n201# A3 0
C254 NAND_a4_3/a_371_n201# XOR_h3/Y 0.00277f
C255 NAND_a4_3/a_371_n201# F2 0
C256 NAND_a4_3/a_371_n201# OR_k3/Y 0
C257 NAND_v3/B OR_p0/Y 0.01989f
C258 NAND_v3/B OR_p1/Y 0.00158f
C259 NAND_v3/B A3 0.4042f
C260 NAND_v3/B OR_p3/Y 0
C261 NAND_v3/B OR_p2/Y 0.01985f
C262 NAND_v3/B F0 0
C263 NAND_v3/B XOR_h3/Y 0.31323f
C264 NAND_v3/B F2 0.12796f
C265 NAND_v3/B OR_k3/Y 0.26165f
C266 NAND_v3/B NAND_v3/A 0.02395f
C267 NAND_v3/B AND_g3/B 0.00199f
C268 NAND_v3/B VDD 0.02497f
C269 NAND_v3/B NAND_u3/A 0.04912f
C270 NAND_v3/B XOR_h3/B 0.00345f
C271 NAND_a4_2/a_371_n201# NAND_v2/B 0.00151f
C272 NAND_a4_2/a_371_n201# NAND_v2/A 0
C273 NAND_v2/B B2 0.80589f
C274 NAND_v2/B NOT_nb2/Y 1.18365f
C275 NAND_v2/B OR_p0/Y 0.05999f
C276 NAND_v2/B B3 0.23666f
C277 NAND_v2/B OR_p1/Y 0.14685f
C278 NAND_v2/B S1 0.08082f
C279 NAND_v2/B OR_p2/a_407_n201# 0.01774f
C280 NAND_v2/B OR_p2/a_494_80# 0.00377f
C281 NAND_v2/B A2 0.6571f
C282 NAND_v2/B OR_p2/B 0.26218f
C283 NAND_v2/B OR_p2/Y 0.82381f
C284 NAND_v2/B NAND_a2_2/a_371_n201# 0
C285 NAND_v2/B F0 0.04275f
C286 NAND_v2/B M 0.11344f
C287 NAND_v2/B F1 0.05013f
C288 NAND_v2/B S2 0.06673f
C289 NAND_v2/B NAND_a3_2/a_371_n201# 0
C290 NAND_v2/B NAND_v2/A 3.35192f
C291 NAND_v2/B S0 0.06044f
C292 NAND_v2/B NAND_v2/a_371_n201# 0.00149f
C293 NAND_v2/B AND_g2/B 0.17397f
C294 NAND_v2/B NAND_u2/a_371_n201# 0
C295 NAND_v2/B NAND_u2/B 0.26041f
C296 NAND_v2/B NAND_a1_2/a_371_n201# 0
C297 NAND_v2/B NAND_u2/A 0.51459f
C298 NAND_v2/B VDD 3.19437f
C299 NAND_v2/B OR_k1/B 0
C300 NAND_v2/B OR_cy1/a_407_n201# 0.03015f
C301 NAND_v2/B OR_cy1/a_494_80# 0.00435f
C302 NAND_v2/B OR_cy1/B 0.00875f
C303 NAND_v2/B OR_k2/B 0.15615f
C304 NAND_v2/B XOR_h0/B 0.05857f
C305 NAND_v2/B XOR_h2/B 0.00148f
C306 NAND_v2/B XOR_h1/B 4.40272f
C307 B2 NOT_nb2/Y 2.63033f
C308 B2 OR_p0/Y 0.0559f
C309 B2 A1 0
C310 B2 OR_p1/Y 0.25845f
C311 B2 S1 0.10905f
C312 B2 OR_p2/a_407_n201# 0
C313 B2 A2 3.47765f
C314 B2 OR_p2/B 0.00539f
C315 B2 OR_p2/Y 0.0633f
C316 B2 XOR_h2/li_n59_n770# 0
C317 B2 F0 0.04534f
C318 B2 M 0.11711f
C319 B2 F1 0.04622f
C320 B2 XOR_f2/li_n59_n770# 0
C321 B2 XOR_f2/m1_n59_n770# 0
C322 B2 OR_k2/Y 0
C323 B2 S2 0.09976f
C324 B2 NAND_v2/A 2.63869f
C325 B2 AND_pc1/a_242_n201# 0.01947f
C326 B2 AND_pc1/a_329_n201# 0.0018f
C327 B2 OR_cy2/B 0
C328 B2 S0 1.02856f
C329 B2 NAND_u2/B 0.00535f
C330 B2 NAND_u2/A 1.09783f
C331 B2 VDD 3.71451f
C332 B2 OR_k1/B 1.63661f
C333 B2 OR_cy1/a_407_n201# 0.00617f
C334 B2 OR_cy1/B 0.21131f
C335 B2 OR_k2/B 0.09837f
C336 B2 XOR_h0/B 0.06131f
C337 B2 XOR_h1/B 0.30959f
C338 NOT_nb2/Y OR_p0/Y 0.06419f
C339 NOT_nb2/Y A1 0
C340 NOT_nb2/Y OR_p1/Y 0.10203f
C341 NOT_nb2/Y S1 0.11358f
C342 NOT_nb2/Y OR_p2/a_407_n201# 0.00662f
C343 NOT_nb2/Y OR_p2/a_494_80# 0.00144f
C344 NOT_nb2/Y A2 0.10083f
C345 NOT_nb2/Y OR_p2/B 0.35693f
C346 NOT_nb2/Y OR_p2/Y 0.15032f
C347 NOT_nb2/Y NAND_a2_2/a_371_n201# 0
C348 NOT_nb2/Y F0 0.17504f
C349 NOT_nb2/Y M 0.02161f
C350 NOT_nb2/Y F1 0.04686f
C351 NOT_nb2/Y S2 0.01291f
C352 NOT_nb2/Y NAND_v2/A 2.89976f
C353 NOT_nb2/Y S0 0.0215f
C354 NOT_nb2/Y NAND_u2/a_371_n201# 0
C355 NOT_nb2/Y NAND_u2/B 0.37999f
C356 NOT_nb2/Y NAND_u2/A 0.38986f
C357 NOT_nb2/Y VDD 1.07634f
C358 NOT_nb2/Y OR_k1/B 0.92908f
C359 NOT_nb2/Y OR_k2/B 0
C360 NOT_nb2/Y XOR_h0/B 0.2419f
C361 NOT_nb2/Y XOR_h1/B 1.35151f
C362 OR_p0/a_407_n201# OR_p0/Y 0.02852f
C363 OR_p0/a_407_n201# S2 0.00364f
C364 OR_p0/a_407_n201# AND_g0/B 0.0308f
C365 OR_p0/a_407_n201# OR_p0/B 0.00123f
C366 OR_p0/a_407_n201# VDD 0
C367 OR_p0/a_494_80# OR_p0/Y 0.00339f
C368 OR_p0/a_494_80# AND_g0/B 0
C369 A0 OR_p0/Y 0.07518f
C370 A0 S1 0.46458f
C371 A0 NAND_u0/B 0.00548f
C372 A0 XOR_h0/li_n59_n770# 0
C373 A0 XOR_h0/m1_n59_n770# 0
C374 A0 XOR_f0/li_n59_n770# 0
C375 A0 XOR_f0/m1_n59_n770# 0
C376 A0 M 0.31392f
C377 A0 OR_k0/Y 0
C378 A0 S2 0.05921f
C379 A0 AND_g0/B 0.07999f
C380 A0 OR_p0/B 0.02068f
C381 A0 S0 0.05809f
C382 A0 NAND_u0/A 1.11061f
C383 A0 VDD 2.54687f
C384 A0 Cn 0.52337f
C385 A0 OR_k0/B 0.06541f
C386 A0 AND_g0/a_242_n201# 0
C387 A0 XOR_h0/B 0.00198f
C388 OR_p0/Y B3 0.06748f
C389 OR_p0/Y NOT_nb3/Y 0.06408f
C390 OR_p0/Y A1 0.0712f
C391 OR_p0/Y OR_p1/Y 1.71117f
C392 OR_p0/Y NAND_u1/B 0.06878f
C393 OR_p0/Y S1 0.13761f
C394 OR_p0/Y NAND_u0/B 0.00491f
C395 OR_p0/Y A3 0.06186f
C396 OR_p0/Y OR_p3/Y 0.06491f
C397 OR_p0/Y A2 0.05793f
C398 OR_p0/Y OR_p2/Y 0.06427f
C399 OR_p0/Y NAND_a2_2/a_371_n201# 0
C400 OR_p0/Y XOR_h0/a_744_n285# 0.04152f
C401 OR_p0/Y XOR_h0/a_831_164# 0.00289f
C402 OR_p0/Y XOR_h0/a_1028_164# 0.02934f
C403 OR_p0/Y XOR_h0/a_1115_n285# 0.0013f
C404 OR_p0/Y XOR_h0/li_n59_n770# 0.0105f
C405 OR_p0/Y XOR_h0/m1_n59_n770# 0.13985f
C406 OR_p0/Y XOR_h0/Y 0.97236f
C407 OR_p0/Y Cn4 0.0714f
C408 OR_p0/Y XOR_h2/Y 0.01387f
C409 OR_p0/Y XOR_f0/a_744_n285# 0.04048f
C410 OR_p0/Y XOR_f0/a_831_164# 0.00288f
C411 OR_p0/Y XOR_f0/a_1028_164# 0.02933f
C412 OR_p0/Y XOR_f0/a_1115_n285# 0
C413 OR_p0/Y XOR_f0/li_n59_n770# 0.01054f
C414 OR_p0/Y XOR_f0/m1_n59_n770# 0.13934f
C415 OR_p0/Y F0 0.88766f
C416 OR_p0/Y OR_k0/a_407_n201# 0.03241f
C417 OR_p0/Y OR_k0/a_494_80# 0.00377f
C418 OR_p0/Y M 1.01887f
C419 OR_p0/Y OR_k0/Y 0.11238f
C420 OR_p0/Y XOR_h3/Y 0.0595f
C421 OR_p0/Y F1 0.06213f
C422 OR_p0/Y XOR_f2/a_744_n285# 0.00413f
C423 OR_p0/Y XOR_f2/a_831_164# 0
C424 OR_p0/Y XOR_f2/a_1028_164# 0
C425 OR_p0/Y XOR_f2/a_1115_n285# 0
C426 OR_p0/Y XOR_f2/li_n59_n770# 0.0131f
C427 OR_p0/Y XOR_f2/m1_n59_n770# 0.13632f
C428 OR_p0/Y F2 0.36328f
C429 OR_p0/Y OR_k2/Y 0.00827f
C430 OR_p0/Y OR_k3/Y 0.0595f
C431 OR_p0/Y S2 0.15184f
C432 OR_p0/Y NAND_v0/A 0.00185f
C433 OR_p0/Y NAND_v1/A 0.00973f
C434 OR_p0/Y AND_pc0/a_242_n201# 0.00502f
C435 OR_p0/Y AND_pc0/a_329_n201# 0
C436 OR_p0/Y OR_cy0/B 0.00245f
C437 OR_p0/Y OR_gr2/B 0.06603f
C438 OR_p0/Y NAND_v2/A 0.0598f
C439 OR_p0/Y NAND_v3/A 0.05975f
C440 OR_p0/Y NAND_v1/a_371_n201# 0
C441 OR_p0/Y AND_g1/B 0.02142f
C442 OR_p0/Y AND_g0/B 0.97623f
C443 OR_p0/Y NAND_u0/a_371_n201# 0
C444 OR_p0/Y OR_p0/B 0.26386f
C445 OR_p0/Y S0 0.67542f
C446 OR_p0/Y NAND_u0/A 0.01447f
C447 OR_p0/Y NAND_u1/A 0.07408f
C448 OR_p0/Y NAND_u2/B 0.0486f
C449 OR_p0/Y NAND_u2/A 0.05604f
C450 OR_p0/Y VDD 3.7583f
C451 OR_p0/Y OR_k0/B 0.34783f
C452 OR_p0/Y AND_pp01/a_242_n201# 0.00731f
C453 OR_p0/Y AND_pp01/a_329_n201# 0.00114f
C454 OR_p0/Y NAND_pg/A 0.0027f
C455 OR_p0/Y NAND_u3/A 0.05541f
C456 OR_p0/Y OR_k1/B 0.06475f
C457 OR_p0/Y OR_k2/B 0.06633f
C458 OR_p0/Y OR_k3/B 0.0602f
C459 OR_p0/Y AND_g0/a_242_n201# 0
C460 OR_p0/Y XOR_h0/B 0.77286f
C461 OR_p0/Y XOR_h2/B 0.0595f
C462 OR_p0/Y XOR_h1/B 0.0559f
C463 OR_p0/Y XOR_h3/B 0.13119f
C464 B3 NOT_nb3/Y 2.13096f
C465 B3 OR_p1/Y 0.06724f
C466 B3 S1 0.06779f
C467 B3 A3 0.05472f
C468 B3 OR_p3/Y 0
C469 B3 A2 0.15033f
C470 B3 OR_p2/Y 0.1402f
C471 B3 XOR_h2/a_744_n285# 0.03799f
C472 B3 XOR_h2/a_831_164# 0.00134f
C473 B3 XOR_h2/a_1028_164# 0.02355f
C474 B3 XOR_h2/a_1115_n285# 0.0013f
C475 B3 XOR_h2/li_n59_n770# 0.01084f
C476 B3 XOR_h2/m1_n59_n770# 0.12491f
C477 B3 XOR_h2/Y 0.5814f
C478 B3 F0 0.10125f
C479 B3 M 0.41341f
C480 B3 XOR_h3/Y 0.06209f
C481 B3 F1 0.10229f
C482 B3 XOR_f2/a_744_n285# 0.0281f
C483 B3 XOR_f2/a_831_164# 0.00134f
C484 B3 XOR_f2/a_1028_164# 0.02355f
C485 B3 XOR_f2/li_n59_n770# 0.01084f
C486 B3 XOR_f2/m1_n59_n770# 0.11949f
C487 B3 F2 1.58344f
C488 B3 OR_k2/a_407_n201# 0.02791f
C489 B3 OR_k2/a_494_80# 0.00339f
C490 B3 OR_k2/Y 0.1063f
C491 B3 OR_k3/Y 0.06714f
C492 B3 S2 0.07239f
C493 B3 NAND_v2/A 0.51564f
C494 B3 NAND_a3_3/a_371_n201# 0
C495 B3 NAND_v3/A 0.11159f
C496 B3 AND_pc2/a_242_n201# 0.02344f
C497 B3 OR_cy2/B 0.07466f
C498 B3 S0 0.02821f
C499 B3 NAND_v2/a_371_n201# 0.00151f
C500 B3 AND_g2/B 0.27502f
C501 B3 VDD 4.77044f
C502 B3 NAND_u3/A 1.13545f
C503 B3 OR_k2/B 0.28072f
C504 B3 OR_cy2/a_407_n201# 0.02924f
C505 B3 OR_cy2/a_494_80# 0.00378f
C506 B3 OR_k3/B 0.20624f
C507 B3 XOR_h0/B 0.05655f
C508 B3 AND_g2/a_242_n201# 0.02532f
C509 B3 XOR_h2/B 6.06944f
C510 B3 XOR_h1/B 0.06398f
C511 B3 XOR_h3/B 0.00629f
C512 NOT_nb3/Y OR_p1/Y 0.062f
C513 NOT_nb3/Y S1 0.01771f
C514 NOT_nb3/Y OR_p3/a_407_n201# 0
C515 NOT_nb3/Y A3 1.84426f
C516 NOT_nb3/Y OR_p3/Y 0.05983f
C517 NOT_nb3/Y OR_p2/Y 0.11464f
C518 NOT_nb3/Y NAND_a2_3/a_371_n201# 0
C519 NOT_nb3/Y NAND_u3/B 0.06859f
C520 NOT_nb3/Y XOR_h2/a_744_n285# 0
C521 NOT_nb3/Y XOR_h2/a_1028_164# 0
C522 NOT_nb3/Y XOR_h2/Y 0.24661f
C523 NOT_nb3/Y F0 0.05253f
C524 NOT_nb3/Y M 0.10985f
C525 NOT_nb3/Y XOR_h3/Y 0.10782f
C526 NOT_nb3/Y F1 0.05664f
C527 NOT_nb3/Y XOR_f3/li_n59_n770# 0
C528 NOT_nb3/Y XOR_f2/a_744_n285# 0.03393f
C529 NOT_nb3/Y XOR_f2/a_1028_164# 0.00121f
C530 NOT_nb3/Y XOR_f2/a_1115_n285# 0.00209f
C531 NOT_nb3/Y XOR_f2/li_n59_n770# 0.01084f
C532 NOT_nb3/Y XOR_f2/m1_n59_n770# 0.13247f
C533 NOT_nb3/Y F2 3.83377f
C534 NOT_nb3/Y OR_k2/a_407_n201# 0.0309f
C535 NOT_nb3/Y OR_k2/a_494_80# 0
C536 NOT_nb3/Y OR_k2/Y 0.25268f
C537 NOT_nb3/Y OR_k3/Y 0.11555f
C538 NOT_nb3/Y S2 0.07299f
C539 NOT_nb3/Y NAND_v3/A 0
C540 NOT_nb3/Y AND_pc2/a_242_n201# 0.01557f
C541 NOT_nb3/Y AND_pc2/a_329_n201# 0.00277f
C542 NOT_nb3/Y OR_cy2/B 0.11621f
C543 NOT_nb3/Y S0 0.01149f
C544 NOT_nb3/Y OR_cy3/B 0
C545 NOT_nb3/Y VDD 2.42708f
C546 NOT_nb3/Y OR_p3/B 0.00546f
C547 NOT_nb3/Y NAND_a1_3/a_371_n201# 0
C548 NOT_nb3/Y NAND_u3/A 1.80514f
C549 NOT_nb3/Y OR_k2/B 1.07027f
C550 NOT_nb3/Y OR_cy2/a_407_n201# 0.0308f
C551 NOT_nb3/Y OR_cy2/a_494_80# 0
C552 NOT_nb3/Y OR_k3/B 0.09651f
C553 NOT_nb3/Y XOR_h0/B 0.05284f
C554 NOT_nb3/Y XOR_h2/B 0.13383f
C555 NOT_nb3/Y XOR_h1/B 0.06066f
C556 OR_p1/a_407_n201# A1 0
C557 OR_p1/a_407_n201# OR_p1/Y 0.03221f
C558 OR_p1/a_407_n201# NAND_u1/B 0
C559 OR_p1/a_407_n201# S2 0.01176f
C560 OR_p1/a_407_n201# OR_p1/B 0.0041f
C561 OR_p1/a_407_n201# NAND_u1/A 0
C562 OR_p1/a_407_n201# VDD 0
C563 OR_p1/a_494_80# OR_p1/Y 0.00359f
C564 OR_p1/a_494_80# S2 0
C565 OR_p1/a_494_80# NAND_u1/A 0
C566 A1 OR_p1/Y 3.81954f
C567 A1 NAND_u1/B 0
C568 A1 S1 0.11036f
C569 A1 F0 0.07784f
C570 A1 M 1.18216f
C571 A1 F1 0.0596f
C572 A1 S2 0.05052f
C573 A1 NAND_v1/A 0.09186f
C574 A1 AND_g1/B 0.02072f
C575 A1 S0 0.0366f
C576 A1 OR_p1/B 0.02647f
C577 A1 NAND_u1/A 1.09771f
C578 A1 NAND_u2/A 0
C579 A1 VDD 4.55749f
C580 A1 OR_k1/B 0
C581 A1 OR_cy1/a_407_n201# 0
C582 A1 OR_cy1/B 0
C583 A1 XOR_h1/B 0.00102f
C584 OR_p1/Y NAND_u1/B 0.00816f
C585 OR_p1/Y S1 0.13143f
C586 OR_p1/Y A3 0.06164f
C587 OR_p1/Y OR_p3/Y 0.24135f
C588 OR_p1/Y A2 1.03909f
C589 OR_p1/Y OR_p2/B 0.00173f
C590 OR_p1/Y OR_p2/Y 1.66975f
C591 OR_p1/Y NAND_a2_2/a_371_n201# 0
C592 OR_p1/Y XOR_h1/li_n59_n770# 0
C593 OR_p1/Y XOR_h1/m1_n59_n770# 0.00192f
C594 OR_p1/Y XOR_h1/Y 0
C595 OR_p1/Y Cn4 0.0672f
C596 OR_p1/Y XOR_h2/Y 0.03756f
C597 OR_p1/Y F0 0.46849f
C598 OR_p1/Y M 1.16918f
C599 OR_p1/Y XOR_h3/Y 0.05928f
C600 OR_p1/Y F1 0.06773f
C601 OR_p1/Y F3 0
C602 OR_p1/Y XOR_f2/li_n59_n770# 0.00251f
C603 OR_p1/Y XOR_f2/m1_n59_n770# 0.00626f
C604 OR_p1/Y F2 0.06691f
C605 OR_p1/Y OR_k2/Y 0.08982f
C606 OR_p1/Y OR_k3/Y 0.04806f
C607 OR_p1/Y P_N 0.02646f
C608 OR_p1/Y S2 0.32147f
C609 OR_p1/Y OR_gr1/B 0
C610 OR_p1/Y NAND_v1/A 1.0013f
C611 OR_p1/Y OR_gr2/B 2.57373f
C612 OR_p1/Y NAND_v2/A 0.44259f
C613 OR_p1/Y AND_pc1/a_242_n201# 0.01698f
C614 OR_p1/Y AND_pc1/a_329_n201# 0
C615 OR_p1/Y NAND_v3/A 0.28486f
C616 OR_p1/Y AND_g1/B 0.00555f
C617 OR_p1/Y S0 0.03515f
C618 OR_p1/Y OR_p1/B 0.21476f
C619 OR_p1/Y NAND_u1/A 0.19477f
C620 OR_p1/Y NAND_u2/B 0.00748f
C621 OR_p1/Y NAND_u2/A 0.13729f
C622 OR_p1/Y VDD 6.09767f
C623 OR_p1/Y AND_pp23/a_242_n201# 0.01496f
C624 OR_p1/Y NAND_pg/B 0.01779f
C625 OR_p1/Y AND_pp01/a_242_n201# 0.0151f
C626 OR_p1/Y NAND_pg/A 0.7938f
C627 OR_p1/Y NAND_u3/A 0.04397f
C628 OR_p1/Y OR_k1/B 0.16433f
C629 OR_p1/Y OR_cy1/a_407_n201# 0
C630 OR_p1/Y OR_cy1/a_494_80# 0
C631 OR_p1/Y OR_cy1/B 0.34924f
C632 OR_p1/Y OR_k2/B 0.08226f
C633 OR_p1/Y OR_k3/B 0.09042f
C634 OR_p1/Y XOR_h0/B 0.07319f
C635 OR_p1/Y XOR_h2/B 0.05928f
C636 OR_p1/Y AND_g1/a_242_n201# 0.00241f
C637 OR_p1/Y XOR_h1/B 0.30163f
C638 OR_p1/Y XOR_h3/B 1.07118f
C639 NAND_a2_1/a_371_n201# F0 0.00277f
C640 NAND_a2_1/a_371_n201# VDD 0
C641 NAND_u1/B S1 0.14362f
C642 NAND_u1/B XOR_h0/a_744_n285# 0
C643 NAND_u1/B XOR_h0/li_n59_n770# 0
C644 NAND_u1/B XOR_h0/m1_n59_n770# 0
C645 NAND_u1/B XOR_h0/Y 0
C646 NAND_u1/B XOR_h1/a_744_n285# 0.00107f
C647 NAND_u1/B XOR_h1/li_n59_n770# 0.0114f
C648 NAND_u1/B XOR_h1/m1_n59_n770# 0.13211f
C649 NAND_u1/B XOR_h1/Y 0.0501f
C650 NAND_u1/B XOR_f0/a_744_n285# 0
C651 NAND_u1/B F0 0.33406f
C652 NAND_u1/B M 0.05244f
C653 NAND_u1/B OR_k0/Y 0
C654 NAND_u1/B XOR_f1/a_744_n285# 0.0101f
C655 NAND_u1/B XOR_f1/a_1028_164# 0
C656 NAND_u1/B XOR_f1/a_1115_n285# 0.00135f
C657 NAND_u1/B XOR_f1/li_n59_n770# 0.0114f
C658 NAND_u1/B XOR_f1/m1_n59_n770# 0.1517f
C659 NAND_u1/B F1 0.37142f
C660 NAND_u1/B OR_k1/a_407_n201# 0.00639f
C661 NAND_u1/B OR_k1/a_494_80# 0
C662 NAND_u1/B OR_k1/Y 0.289f
C663 NAND_u1/B S2 1.21051f
C664 NAND_u1/B NAND_v1/A 0.00597f
C665 NAND_u1/B NAND_v1/a_371_n201# 0
C666 NAND_u1/B AND_g1/B 0.25669f
C667 NAND_u1/B S0 0.10237f
C668 NAND_u1/B NAND_u1/a_371_n201# 0.00149f
C669 NAND_u1/B OR_p1/B 0.16102f
C670 NAND_u1/B NAND_u1/A 0.0943f
C671 NAND_u1/B VDD 0.30952f
C672 NAND_u1/B OR_k1/B 0.30642f
C673 NAND_u1/B XOR_h0/B 0.05728f
C674 NAND_u1/B AND_g1/a_242_n201# 0
C675 NAND_u1/B AND_g1/a_329_n201# 0
C676 NAND_u1/B XOR_h1/B 1.37755f
C677 NAND_a2_0/a_371_n201# NAND_u0/B 0
C678 NAND_a2_0/a_371_n201# AND_g0/B 0.00277f
C679 S1 NAND_u0/B 0
C680 S1 A3 0
C681 S1 A2 0.06213f
C682 S1 XOR_h0/Y 0.04187f
C683 S1 NAND_u3/B 0
C684 S1 XOR_f0/a_744_n285# 0.00275f
C685 S1 XOR_f0/a_831_164# 0
C686 S1 XOR_f0/a_1028_164# 0
C687 S1 XOR_f0/li_n59_n770# 0.01272f
C688 S1 XOR_f0/m1_n59_n770# 0.14799f
C689 S1 F0 0.62415f
C690 S1 M 0.10389f
C691 S1 OR_k0/Y 0.13637f
C692 S1 F1 0.05062f
C693 S1 S2 2.51954f
C694 S1 NAND_v0/A 0
C695 S1 NAND_v1/A 0.27492f
C696 S1 AND_pc0/a_242_n201# 0
C697 S1 OR_cy0/B 0.24488f
C698 S1 NAND_v2/A 0.53479f
C699 S1 AND_pc1/a_242_n201# 0.00581f
C700 S1 AND_pc1/a_329_n201# 0
C701 S1 AND_g0/B 0.68176f
C702 S1 NAND_a1_0/a_371_n201# 0
C703 S1 S0 3.61416f
C704 S1 NAND_u0/A 0.07289f
C705 S1 NAND_v2/a_371_n201# 0
C706 S1 AND_g2/B 0.00402f
C707 S1 NAND_u1/a_371_n201# 0
C708 S1 OR_p1/B 0.00428f
C709 S1 NAND_a1_1/a_371_n201# 0
C710 S1 NAND_u1/A 0.13532f
C711 S1 NAND_u2/B 0
C712 S1 NAND_a1_2/a_371_n201# 0
C713 S1 NAND_u2/A 0.01777f
C714 S1 VDD 2.49079f
C715 S1 Cn 0.39275f
C716 S1 OR_k0/B 1.65308f
C717 S1 OR_cy0/a_407_n201# 0
C718 S1 OR_k1/B 1.0687f
C719 S1 OR_cy1/B 0.00233f
C720 S1 AND_g0/a_242_n201# 0.00537f
C721 S1 AND_g0/a_329_n201# 0
C722 S1 XOR_h0/B 0.06587f
C723 S1 XOR_h1/B 0.00473f
C724 NAND_u0/B S2 0.25666f
C725 NAND_u0/B AND_g0/B 0.31634f
C726 NAND_u0/B NAND_u0/a_371_n201# 0
C727 NAND_u0/B OR_p0/B 0.00248f
C728 NAND_u0/B NAND_u0/A 0.03199f
C729 NAND_u0/B VDD 0.01651f
C730 OR_p3/a_407_n201# A3 0.00654f
C731 OR_p3/a_407_n201# OR_p3/Y 0.03687f
C732 OR_p3/a_407_n201# XOR_h3/Y 0.02075f
C733 OR_p3/a_407_n201# OR_k3/Y 0.01655f
C734 OR_p3/a_407_n201# S2 0.00207f
C735 OR_p3/a_407_n201# VDD 0
C736 OR_p3/a_407_n201# OR_p3/B 0.00113f
C737 OR_p3/a_407_n201# NAND_u3/A 0.01112f
C738 OR_p3/a_494_80# OR_p3/Y 0
C739 OR_p3/a_494_80# OR_k3/Y 0.00335f
C740 OR_p3/a_494_80# NAND_u3/A 0.00204f
C741 A3 OR_p3/Y 1.54388f
C742 A3 OR_p2/Y 0.13666f
C743 A3 NAND_u3/B 0.00349f
C744 A3 XOR_h2/li_n59_n770# 0
C745 A3 XOR_h2/m1_n59_n770# 0
C746 A3 F0 0.04534f
C747 A3 XOR_h3/Y 3.5574f
C748 A3 F1 0.04604f
C749 A3 XOR_f3/a_744_n285# 0
C750 A3 XOR_f3/li_n59_n770# 0
C751 A3 XOR_f3/m1_n59_n770# 0
C752 A3 F2 0.08618f
C753 A3 OR_k3/Y 0.18349f
C754 A3 S2 1.14563f
C755 A3 NAND_a3_3/a_371_n201# 0
C756 A3 NAND_v3/A 0.12604f
C757 A3 AND_pc3/a_242_n201# 0
C758 A3 AND_g3/B 0.02992f
C759 A3 VDD 2.74388f
C760 A3 OR_p3/B 0.19847f
C761 A3 NAND_u3/A 1.37235f
C762 A3 OR_k3/B 0
C763 A3 XOR_h0/B 0.06167f
C764 A3 XOR_h2/B 0.06266f
C765 A3 XOR_h3/B 0.0078f
C766 OR_p3/Y OR_p2/Y 0.20274f
C767 OR_p3/Y Cn4 0.55259f
C768 OR_p3/Y F0 0.05475f
C769 OR_p3/Y M 0.03615f
C770 OR_p3/Y XOR_h3/li_n59_n770# 0
C771 OR_p3/Y XOR_h3/m1_n59_n770# 0.00201f
C772 OR_p3/Y XOR_h3/Y 0.96898f
C773 OR_p3/Y F1 0.05574f
C774 OR_p3/Y F3 0.14118f
C775 OR_p3/Y F2 0.18338f
C776 OR_p3/Y OR_k3/Y 0.97161f
C777 OR_p3/Y S2 0.01604f
C778 OR_p3/Y AND_q3/a_242_n201# 0.01788f
C779 OR_p3/Y AND_q3/a_329_n201# 0.00131f
C780 OR_p3/Y NOR_gg/B 0.03113f
C781 OR_p3/Y OR_gr2/B 1.3073f
C782 OR_p3/Y NAND_v3/A 0.09358f
C783 OR_p3/Y AND_pc3/a_242_n201# 0.00823f
C784 OR_p3/Y AND_pc3/a_329_n201# 0
C785 OR_p3/Y OR_cy3/B 0.48152f
C786 OR_p3/Y AND_g3/B 0.00558f
C787 OR_p3/Y VDD 3.15006f
C788 OR_p3/Y NAND_pg/B 0
C789 OR_p3/Y AND_pp01/a_242_n201# 0.00563f
C790 OR_p3/Y AND_pp01/a_329_n201# 0.00149f
C791 OR_p3/Y NAND_pg/A 0.01434f
C792 OR_p3/Y OR_p3/B 0.01818f
C793 OR_p3/Y NAND_u3/A 1.09426f
C794 OR_p3/Y OR_gr2/Y 0.0921f
C795 OR_p3/Y OR_k3/B 2.26164f
C796 OR_p3/Y XOR_h0/B 0.05977f
C797 OR_p3/Y OR_cy3/a_407_n201# 0.01922f
C798 OR_p3/Y OR_cy3/a_494_80# 0
C799 OR_p3/Y OR_cy3/Y 0.12941f
C800 OR_p3/Y XOR_h2/B 0.05841f
C801 OR_p3/Y XOR_h1/B 0.0599f
C802 OR_p3/Y AND_g3/a_242_n201# 0.00241f
C803 OR_p3/Y XOR_h3/B 1.82806f
C804 OR_p2/a_407_n201# OR_p2/B 0.00111f
C805 OR_p2/a_407_n201# OR_p2/Y 0.03789f
C806 OR_p2/a_407_n201# S2 0.00362f
C807 OR_p2/a_407_n201# NAND_v2/A 0.02075f
C808 OR_p2/a_407_n201# VDD 0
C809 OR_p2/a_407_n201# XOR_h0/B 0
C810 OR_p2/a_407_n201# XOR_h1/B 0
C811 OR_p2/a_494_80# OR_p2/Y 0.00155f
C812 A2 OR_p2/B 0.02016f
C813 A2 OR_p2/Y 0.01402f
C814 A2 XOR_h2/a_744_n285# 0
C815 A2 XOR_h2/li_n59_n770# 0
C816 A2 XOR_h2/m1_n59_n770# 0
C817 A2 F0 0.04736f
C818 A2 M 0.05858f
C819 A2 F1 0.04807f
C820 A2 XOR_f2/a_744_n285# 0
C821 A2 XOR_f2/li_n59_n770# 0
C822 A2 XOR_f2/m1_n59_n770# 0
C823 A2 OR_k2/a_407_n201# 0
C824 A2 OR_k2/Y 0
C825 A2 S2 0.05853f
C826 A2 NAND_v2/A 1.23488f
C827 A2 AND_pc1/a_242_n201# 0
C828 A2 S0 0
C829 A2 AND_g2/B 0.13602f
C830 A2 NAND_u2/B 0.00389f
C831 A2 NAND_u2/A 0.09209f
C832 A2 VDD 5.70179f
C833 A2 OR_k1/B 0
C834 A2 OR_cy1/a_407_n201# 0
C835 A2 OR_cy1/B 0.00692f
C836 A2 OR_k2/B 0.06521f
C837 A2 XOR_h0/B 0.05989f
C838 A2 AND_g2/a_242_n201# 0
C839 A2 AND_g2/a_329_n201# 0
C840 A2 XOR_h2/B 0.30493f
C841 A2 XOR_h1/B 1.94002f
C842 OR_p2/B OR_p2/Y 0.01013f
C843 OR_p2/B XOR_h1/li_n59_n770# 0
C844 OR_p2/B XOR_h1/m1_n59_n770# 0
C845 OR_p2/B S2 0.02309f
C846 OR_p2/B NAND_v2/A 0.30196f
C847 OR_p2/B NAND_u2/B 0.00215f
C848 OR_p2/B VDD 0.01437f
C849 OR_p2/B OR_k1/B 0.25475f
C850 OR_p2/B XOR_h0/B 0.14199f
C851 OR_p2/B XOR_h1/B 0.31429f
C852 OR_p2/Y Cn4 0.07371f
C853 OR_p2/Y XOR_h2/a_744_n285# 0.00102f
C854 OR_p2/Y XOR_h2/a_1028_164# 0
C855 OR_p2/Y XOR_h2/li_n59_n770# 0.01291f
C856 OR_p2/Y XOR_h2/m1_n59_n770# 0.15955f
C857 OR_p2/Y XOR_h2/Y 1.09452f
C858 OR_p2/Y F0 0.0501f
C859 OR_p2/Y M 1.15433f
C860 OR_p2/Y XOR_h3/Y 0.06743f
C861 OR_p2/Y F1 0.05081f
C862 OR_p2/Y F3 0
C863 OR_p2/Y XOR_f2/a_744_n285# 0.00263f
C864 OR_p2/Y XOR_f2/a_831_164# 0
C865 OR_p2/Y XOR_f2/a_1028_164# 0.00321f
C866 OR_p2/Y XOR_f2/li_n59_n770# 0.0114f
C867 OR_p2/Y XOR_f2/m1_n59_n770# 0.14532f
C868 OR_p2/Y F2 0.13661f
C869 OR_p2/Y OR_k2/a_407_n201# 0
C870 OR_p2/Y OR_k2/Y 0.00361f
C871 OR_p2/Y OR_k3/Y 0.06064f
C872 OR_p2/Y P_N 0.00767f
C873 OR_p2/Y S2 0.08726f
C874 OR_p2/Y AND_q1/a_242_n201# 0
C875 OR_p2/Y OR_gr1/B 0.0034f
C876 OR_p2/Y OR_gr2/B 0.63299f
C877 OR_p2/Y NAND_v2/A 0.7683f
C878 OR_p2/Y NAND_v3/A 0.00837f
C879 OR_p2/Y AND_pc2/a_242_n201# 0.00249f
C880 OR_p2/Y OR_cy2/B 0.15226f
C881 OR_p2/Y S0 0
C882 OR_p2/Y NAND_v3/a_371_n201# 0
C883 OR_p2/Y AND_g3/B 0.02134f
C884 OR_p2/Y VDD 8.75191f
C885 OR_p2/Y AND_pp23/a_242_n201# 0.01307f
C886 OR_p2/Y AND_pp23/a_329_n201# 0
C887 OR_p2/Y NAND_pg/B 0.02811f
C888 OR_p2/Y NAND_pg/A 0.91627f
C889 OR_p2/Y OR_p3/B 0
C890 OR_p2/Y NAND_u3/A 0.05655f
C891 OR_p2/Y OR_gr1/a_407_n201# 0.00527f
C892 OR_p2/Y OR_gr1/a_494_80# 0.00144f
C893 OR_p2/Y OR_gr1/Y 0.01884f
C894 OR_p2/Y OR_k2/B 0.01403f
C895 OR_p2/Y OR_cy2/a_407_n201# 0.00258f
C896 OR_p2/Y OR_cy2/a_494_80# 0
C897 OR_p2/Y OR_k3/B 0.06898f
C898 OR_p2/Y XOR_h0/B 0.27249f
C899 OR_p2/Y XOR_h2/B 2.0255f
C900 OR_p2/Y XOR_h1/B 1.03668f
C901 OR_p2/Y XOR_h3/B 0.05929f
C902 NAND_a2_2/a_371_n201# NAND_v2/A 0.00277f
C903 XOR_h0/a_744_n285# XOR_h0/m1_n59_n770# 0
C904 XOR_h0/a_744_n285# XOR_h0/Y 0
C905 XOR_h0/a_744_n285# M 0.00851f
C906 XOR_h0/a_744_n285# S2 0.00453f
C907 XOR_h0/a_744_n285# NAND_u1/A 0
C908 XOR_h0/a_744_n285# VDD 0
C909 XOR_h0/a_744_n285# OR_k0/B 0.01572f
C910 XOR_h0/a_744_n285# XOR_h0/B 0.00102f
C911 XOR_h0/a_831_164# M 0.00286f
C912 XOR_h0/a_831_164# S2 0
C913 XOR_h0/a_1028_164# M 0.01187f
C914 XOR_h0/a_1028_164# S2 0.00154f
C915 XOR_h0/a_1028_164# OR_k0/B 0.00101f
C916 XOR_h0/a_1028_164# XOR_h0/B 0
C917 XOR_h0/a_1115_n285# S2 0
C918 XOR_h0/a_1115_n285# OR_k0/B 0.00169f
C919 XOR_h0/li_n59_n770# M 0.01144f
C920 XOR_h0/li_n59_n770# S2 0.00614f
C921 XOR_h0/li_n59_n770# AND_g0/B 0
C922 XOR_h0/li_n59_n770# OR_p1/B 0.00212f
C923 XOR_h0/li_n59_n770# NAND_u1/A 0.00942f
C924 XOR_h0/li_n59_n770# VDD 0.01175f
C925 XOR_h0/li_n59_n770# OR_k0/B 0.01096f
C926 XOR_h0/li_n59_n770# XOR_h0/B 0.0132f
C927 XOR_h0/m1_n59_n770# M 0.12853f
C928 XOR_h0/m1_n59_n770# S2 0.07389f
C929 XOR_h0/m1_n59_n770# AND_g0/B 0
C930 XOR_h0/m1_n59_n770# OR_p1/B 0.00169f
C931 XOR_h0/m1_n59_n770# NAND_u1/A 0.10937f
C932 XOR_h0/m1_n59_n770# VDD 0.02198f
C933 XOR_h0/m1_n59_n770# OR_k0/B 0.15108f
C934 XOR_h0/m1_n59_n770# XOR_h0/B 0.12457f
C935 XOR_h0/Y XOR_f0/li_n59_n770# 0
C936 XOR_h0/Y XOR_f0/m1_n59_n770# 0.00191f
C937 XOR_h0/Y F0 0.00613f
C938 XOR_h0/Y OR_k0/a_407_n201# 0.01146f
C939 XOR_h0/Y OR_k0/a_494_80# 0.00215f
C940 XOR_h0/Y M 0.11204f
C941 XOR_h0/Y OR_k0/Y 0.02148f
C942 XOR_h0/Y S2 0.00223f
C943 XOR_h0/Y S0 0.22535f
C944 XOR_h0/Y NAND_u1/A 0.01011f
C945 XOR_h0/Y VDD 0.56981f
C946 XOR_h0/Y OR_k0/B 0.09794f
C947 XOR_h0/Y XOR_h0/B 1.04886f
C948 NAND_a2_3/a_371_n201# NAND_u3/B 0
C949 NAND_u3/B XOR_h3/Y 0.01383f
C950 NAND_u3/B OR_k3/Y 0.00619f
C951 NAND_u3/B VDD 0.02207f
C952 NAND_u3/B OR_p3/B 0.00192f
C953 NAND_u3/B NAND_u3/A 0.02151f
C954 NAND_u3/B XOR_h2/B 0.30407f
C955 XOR_h1/a_744_n285# XOR_h1/m1_n59_n770# 0
C956 XOR_h1/a_744_n285# XOR_h1/Y 0
C957 XOR_h1/a_744_n285# M 0.00851f
C958 XOR_h1/a_744_n285# F1 0.04151f
C959 XOR_h1/a_744_n285# S2 0.0056f
C960 XOR_h1/a_744_n285# NAND_u1/A 0
C961 XOR_h1/a_744_n285# VDD 0
C962 XOR_h1/a_744_n285# XOR_h1/B 0.01819f
C963 XOR_h1/a_831_164# M 0.00286f
C964 XOR_h1/a_831_164# F1 0.00288f
C965 XOR_h1/a_831_164# S2 0
C966 XOR_h1/a_831_164# XOR_h1/B 0
C967 XOR_h1/a_1028_164# M 0.01187f
C968 XOR_h1/a_1028_164# F1 0.02933f
C969 XOR_h1/a_1028_164# S2 0.00186f
C970 XOR_h1/a_1028_164# XOR_h1/B 0.0025f
C971 XOR_h1/a_1115_n285# F1 0.0013f
C972 XOR_h1/a_1115_n285# S2 0
C973 XOR_h1/a_1115_n285# XOR_h1/B 0.00199f
C974 XOR_h1/li_n59_n770# M 0.01144f
C975 XOR_h1/li_n59_n770# F1 0.01083f
C976 XOR_h1/li_n59_n770# S2 0.01519f
C977 XOR_h1/li_n59_n770# NAND_v2/A 0
C978 XOR_h1/li_n59_n770# NAND_u1/A 0
C979 XOR_h1/li_n59_n770# VDD 0.01174f
C980 XOR_h1/li_n59_n770# OR_k1/B 0.00476f
C981 XOR_h1/li_n59_n770# XOR_h0/B 0.00244f
C982 XOR_h1/li_n59_n770# XOR_h1/B 0.01216f
C983 XOR_h1/m1_n59_n770# M 0.14589f
C984 XOR_h1/m1_n59_n770# F1 0.13789f
C985 XOR_h1/m1_n59_n770# S2 0.13108f
C986 XOR_h1/m1_n59_n770# NAND_v2/A 0
C987 XOR_h1/m1_n59_n770# NAND_u1/A 0
C988 XOR_h1/m1_n59_n770# VDD 0.03345f
C989 XOR_h1/m1_n59_n770# OR_k1/B 0.00929f
C990 XOR_h1/m1_n59_n770# XOR_h0/B 0.00343f
C991 XOR_h1/m1_n59_n770# XOR_h1/B 0.13705f
C992 XOR_h1/Y M 0.04703f
C993 XOR_h1/Y XOR_f1/li_n59_n770# 0
C994 XOR_h1/Y XOR_f1/m1_n59_n770# 0.00234f
C995 XOR_h1/Y F1 1.01347f
C996 XOR_h1/Y OR_k1/a_407_n201# 0.01317f
C997 XOR_h1/Y OR_k1/a_494_80# 0.00231f
C998 XOR_h1/Y OR_k1/Y 0.01522f
C999 XOR_h1/Y S2 0.00279f
C1000 XOR_h1/Y S0 0.28311f
C1001 XOR_h1/Y VDD 0.95052f
C1002 XOR_h1/Y OR_k1/B 0.06983f
C1003 XOR_h1/Y XOR_h1/B 0.09572f
C1004 Cn4 F0 0.0444f
C1005 Cn4 F1 0.06769f
C1006 Cn4 F3 0.22174f
C1007 Cn4 F2 0.0652f
C1008 Cn4 NAND_pg/a_371_n201# 0.00277f
C1009 Cn4 P_N 3.58225f
C1010 Cn4 AND_q1/a_242_n201# 0.01557f
C1011 Cn4 AND_q1/a_329_n201# 0.00277f
C1012 Cn4 OR_gr1/B 0.12268f
C1013 Cn4 AND_q2/a_242_n201# 0.02678f
C1014 Cn4 AND_q2/a_329_n201# 0.00277f
C1015 Cn4 OR_gr2/B 2.99172f
C1016 Cn4 VDD 0.24913f
C1017 Cn4 AND_pp23/a_242_n201# 0.01866f
C1018 Cn4 AND_pp23/a_329_n201# 0.00283f
C1019 Cn4 NAND_pg/B 0.25978f
C1020 Cn4 AND_pp01/a_242_n201# 0.04051f
C1021 Cn4 AND_pp01/a_329_n201# 0.00202f
C1022 Cn4 NAND_pg/A 0.72316f
C1023 Cn4 OR_gr1/a_407_n201# 0.0308f
C1024 Cn4 OR_gr1/a_494_80# 0
C1025 Cn4 OR_gr1/Y 0.16448f
C1026 Cn4 OR_k3/B 0.32314f
C1027 Cn4 XOR_h0/B 0.5638f
C1028 Cn4 OR_cy3/Y 0
C1029 Cn4 XOR_h1/B 0.06964f
C1030 Cn4 XOR_h3/B 0.0645f
C1031 XOR_h2/a_744_n285# XOR_h2/m1_n59_n770# 0
C1032 XOR_h2/a_744_n285# XOR_h2/Y 0
C1033 XOR_h2/a_744_n285# M 0.01107f
C1034 XOR_h2/a_744_n285# VDD 0
C1035 XOR_h2/a_744_n285# OR_k2/B 0.01572f
C1036 XOR_h2/a_744_n285# XOR_h2/B 0.01473f
C1037 XOR_h2/a_831_164# M 0.00153f
C1038 XOR_h2/a_831_164# XOR_h2/B 0.0037f
C1039 XOR_h2/a_1028_164# M 0.00664f
C1040 XOR_h2/a_1028_164# OR_k2/B 0.00101f
C1041 XOR_h2/a_1028_164# XOR_h2/B 0.02031f
C1042 XOR_h2/a_1115_n285# M 0
C1043 XOR_h2/a_1115_n285# OR_k2/B 0.00169f
C1044 XOR_h2/li_n59_n770# M 0.0101f
C1045 XOR_h2/li_n59_n770# XOR_h3/Y 0
C1046 XOR_h2/li_n59_n770# S2 0.00669f
C1047 XOR_h2/li_n59_n770# VDD 0.01858f
C1048 XOR_h2/li_n59_n770# OR_p3/B 0.00212f
C1049 XOR_h2/li_n59_n770# OR_k2/B 0.01175f
C1050 XOR_h2/li_n59_n770# XOR_h2/B 0.01283f
C1051 XOR_h2/m1_n59_n770# M 0.20708f
C1052 XOR_h2/m1_n59_n770# XOR_h3/Y 0
C1053 XOR_h2/m1_n59_n770# S2 0.05077f
C1054 XOR_h2/m1_n59_n770# VDD 0.042f
C1055 XOR_h2/m1_n59_n770# OR_p3/B 0.00169f
C1056 XOR_h2/m1_n59_n770# OR_k2/B 0.15206f
C1057 XOR_h2/m1_n59_n770# XOR_h2/B 0.11684f
C1058 XOR_h2/Y F0 0.04572f
C1059 XOR_h2/Y M 0.0983f
C1060 XOR_h2/Y F1 0.04614f
C1061 XOR_h2/Y XOR_f2/li_n59_n770# 0
C1062 XOR_h2/Y XOR_f2/m1_n59_n770# 0.00196f
C1063 XOR_h2/Y F2 0.00897f
C1064 XOR_h2/Y OR_k2/a_407_n201# 0.00685f
C1065 XOR_h2/Y OR_k2/a_494_80# 0
C1066 XOR_h2/Y OR_k2/Y 0.01691f
C1067 XOR_h2/Y VDD 0.50629f
C1068 XOR_h2/Y OR_k2/B 0.06542f
C1069 XOR_h2/Y XOR_h2/B 1.13836f
C1070 XOR_f0/a_744_n285# XOR_f0/m1_n59_n770# 0
C1071 XOR_f0/a_744_n285# F0 0.0132f
C1072 XOR_f0/a_744_n285# S0 0.02773f
C1073 XOR_f0/a_744_n285# NAND_u1/A 0
C1074 XOR_f0/a_744_n285# VDD 0
C1075 XOR_f0/a_744_n285# OR_k0/B 0.00197f
C1076 XOR_f0/a_744_n285# XOR_h0/B 0.00536f
C1077 XOR_f0/a_831_164# F0 0.00107f
C1078 XOR_f0/a_831_164# XOR_h0/B 0.00219f
C1079 XOR_f0/a_1028_164# F0 0.00647f
C1080 XOR_f0/a_1028_164# S0 0.00163f
C1081 XOR_f0/a_1028_164# XOR_h0/B 0.00796f
C1082 XOR_f0/a_1115_n285# S0 0.00239f
C1083 XOR_f0/li_n59_n770# OR_k0/Y 0.00162f
C1084 XOR_f0/li_n59_n770# S0 0.01111f
C1085 XOR_f0/li_n59_n770# NAND_u0/A 0
C1086 XOR_f0/li_n59_n770# NAND_u1/A 0.01084f
C1087 XOR_f0/li_n59_n770# VDD 0.01778f
C1088 XOR_f0/li_n59_n770# OR_k0/B 0.01272f
C1089 XOR_f0/li_n59_n770# XOR_h0/B 0.01139f
C1090 XOR_f0/m1_n59_n770# F0 0.00263f
C1091 XOR_f0/m1_n59_n770# OR_k0/Y 0.00427f
C1092 XOR_f0/m1_n59_n770# S0 0.12658f
C1093 XOR_f0/m1_n59_n770# NAND_u0/A 0
C1094 XOR_f0/m1_n59_n770# NAND_u1/A 0.11001f
C1095 XOR_f0/m1_n59_n770# VDD 0.03313f
C1096 XOR_f0/m1_n59_n770# OR_k0/B 0.12447f
C1097 XOR_f0/m1_n59_n770# XOR_h0/B 0.13684f
C1098 F0 M 0.04601f
C1099 F0 OR_k0/Y 0.00439f
C1100 F0 XOR_h3/Y 0.04942f
C1101 F0 F1 5.67629f
C1102 F0 F3 0.08143f
C1103 F0 XOR_f2/li_n59_n770# 0
C1104 F0 XOR_f2/m1_n59_n770# 0
C1105 F0 F2 0.05741f
C1106 F0 OR_k2/a_407_n201# 0
C1107 F0 OR_k2/Y 0.09918f
C1108 F0 OR_k3/Y 0.04913f
C1109 F0 S2 0.06217f
C1110 F0 NAND_v1/A 0.04707f
C1111 F0 AND_pc0/a_242_n201# 0.0486f
C1112 F0 AND_pc0/a_329_n201# 0.00205f
C1113 F0 OR_cy0/B 0.24773f
C1114 F0 OR_gr2/B 0.05469f
C1115 F0 NAND_v2/A 0.04684f
C1116 F0 NAND_v3/A 0.07665f
C1117 F0 AND_g1/B 0
C1118 F0 S0 2.14384f
C1119 F0 NAND_a1_1/a_371_n201# 0.00277f
C1120 F0 NAND_u1/A 0.33722f
C1121 F0 NAND_u2/B 0
C1122 F0 NAND_u2/A 0.04885f
C1123 F0 VDD 2.80103f
C1124 F0 OR_k0/B 0.01585f
C1125 F0 NAND_u3/A 0.04504f
C1126 F0 G_N 0.40665f
C1127 F0 OR_cy0/a_407_n201# 0.03414f
C1128 F0 OR_cy0/a_494_80# 0.00215f
C1129 F0 OR_k1/B 0.60601f
C1130 F0 OR_k2/B 0.05585f
C1131 F0 OR_k3/B 0.05389f
C1132 F0 XOR_h0/B 0.56785f
C1133 F0 OR_cy3/Y 0
C1134 F0 XOR_h2/B 0.04534f
C1135 F0 XOR_h1/B 0.04285f
C1136 F0 XOR_h3/B 0.25452f
C1137 OR_k0/a_407_n201# OR_k0/Y 0.00235f
C1138 OR_k0/a_407_n201# S0 0.01977f
C1139 OR_k0/a_407_n201# NAND_u1/A 0
C1140 OR_k0/a_407_n201# VDD 0
C1141 OR_k0/a_407_n201# OR_k0/B 0
C1142 OR_k0/a_407_n201# XOR_h0/B 0
C1143 OR_k0/a_494_80# S0 0
C1144 M OR_k0/Y 0
C1145 M XOR_h3/a_744_n285# 0.01042f
C1146 M XOR_h3/a_831_164# 0.00153f
C1147 M XOR_h3/a_1028_164# 0.00663f
C1148 M XOR_h3/a_1115_n285# 0
C1149 M XOR_h3/li_n59_n770# 0.01006f
C1150 M XOR_h3/m1_n59_n770# 0.21065f
C1151 M XOR_h3/Y 0.07192f
C1152 M F1 3.1524f
C1153 M OR_k1/Y 0
C1154 M F2 0.06299f
C1155 M OR_k2/Y 0
C1156 M OR_k3/Y 0.07104f
C1157 M S2 0.98274f
C1158 M NAND_a3_1/a_371_n201# 0.00211f
C1159 M NAND_v1/A 1.34998f
C1160 M NAND_v2/A 0.11128f
C1161 M AND_g1/B 0.0484f
C1162 M AND_g0/B 0.15415f
C1163 M S0 4.09528f
C1164 M NAND_u1/A 0.05682f
C1165 M VDD 6.21391f
C1166 M Cn 0
C1167 M OR_k0/B 0.01867f
C1168 M NAND_u3/A 1.19388f
C1169 M OR_k1/B 0.1332f
C1170 M OR_k2/B 0.0751f
C1171 M OR_cy2/a_407_n201# 0
C1172 M OR_k3/B 0.58304f
C1173 M AND_g0/a_242_n201# 0.02897f
C1174 M AND_g0/a_329_n201# 0.00116f
C1175 M XOR_h0/B 1.70797f
C1176 M XOR_h2/B 1.19916f
C1177 M AND_g1/a_242_n201# 0.01496f
C1178 M XOR_h1/B 0.4977f
C1179 M XOR_h3/B 0.00954f
C1180 OR_k0/Y S0 0.31205f
C1181 OR_k0/Y NAND_u1/A 0.00147f
C1182 OR_k0/Y VDD 0.01459f
C1183 OR_k0/Y OR_k0/B 0.18802f
C1184 OR_k0/Y XOR_h0/B 0.00536f
C1185 XOR_h3/a_744_n285# XOR_h3/m1_n59_n770# 0
C1186 XOR_h3/a_744_n285# XOR_h3/Y 0.03937f
C1187 XOR_h3/a_744_n285# OR_k3/Y 0.03281f
C1188 XOR_h3/a_744_n285# VDD 0
C1189 XOR_h3/a_744_n285# NAND_u3/A 0.01473f
C1190 XOR_h3/a_744_n285# OR_k3/B 0.00761f
C1191 XOR_h3/a_831_164# OR_k3/Y 0.00134f
C1192 XOR_h3/a_831_164# NAND_u3/A 0.0037f
C1193 XOR_h3/a_1028_164# XOR_h3/Y 0.00274f
C1194 XOR_h3/a_1028_164# OR_k3/Y 0.02355f
C1195 XOR_h3/a_1028_164# NAND_u3/A 0.02031f
C1196 XOR_h3/a_1115_n285# XOR_h3/Y 0.00209f
C1197 XOR_h3/a_1115_n285# OR_k3/B 0.00151f
C1198 XOR_h3/li_n59_n770# XOR_h3/Y 0.01084f
C1199 XOR_h3/li_n59_n770# OR_k3/Y 0.01084f
C1200 XOR_h3/li_n59_n770# VDD 0.01176f
C1201 XOR_h3/li_n59_n770# NAND_u3/A 0.01111f
C1202 XOR_h3/li_n59_n770# OR_k3/B 0.01488f
C1203 XOR_h3/li_n59_n770# XOR_h0/B 0
C1204 XOR_h3/li_n59_n770# XOR_h1/B 0.00268f
C1205 XOR_h3/li_n59_n770# XOR_h3/B 0.00245f
C1206 XOR_h3/m1_n59_n770# XOR_h3/Y 0.13247f
C1207 XOR_h3/m1_n59_n770# OR_k3/Y 0.11949f
C1208 XOR_h3/m1_n59_n770# VDD 0.03354f
C1209 XOR_h3/m1_n59_n770# NAND_u3/A 0.11583f
C1210 XOR_h3/m1_n59_n770# OR_k3/B 0.17818f
C1211 XOR_h3/m1_n59_n770# XOR_h1/B 0.00382f
C1212 XOR_h3/m1_n59_n770# XOR_h3/B 0.00532f
C1213 XOR_h3/Y F1 0.05013f
C1214 XOR_h3/Y XOR_f3/a_744_n285# 0.01799f
C1215 XOR_h3/Y XOR_f3/a_831_164# 0.00272f
C1216 XOR_h3/Y XOR_f3/a_1028_164# 0.01486f
C1217 XOR_h3/Y XOR_f3/a_1115_n285# 0
C1218 XOR_h3/Y XOR_f3/li_n59_n770# 0.01003f
C1219 XOR_h3/Y XOR_f3/m1_n59_n770# 0.15282f
C1220 XOR_h3/Y F3 0.08339f
C1221 XOR_h3/Y F2 0.0595f
C1222 XOR_h3/Y OR_k3/a_407_n201# 0.0013f
C1223 XOR_h3/Y OR_k3/Y 4.3263f
C1224 XOR_h3/Y S2 0.01242f
C1225 XOR_h3/Y OR_gr2/B 0.27631f
C1226 XOR_h3/Y NAND_a3_3/a_371_n201# 0.00277f
C1227 XOR_h3/Y NAND_v3/A 0.49844f
C1228 XOR_h3/Y AND_pc3/a_242_n201# 0.00235f
C1229 XOR_h3/Y AND_pc3/a_329_n201# 0
C1230 XOR_h3/Y OR_cy3/B 0
C1231 XOR_h3/Y NAND_v3/a_371_n201# 0.00277f
C1232 XOR_h3/Y AND_g3/B 0.40803f
C1233 XOR_h3/Y VDD 1.34188f
C1234 XOR_h3/Y NAND_u3/a_371_n201# 0.00319f
C1235 XOR_h3/Y OR_p3/B 0.39682f
C1236 XOR_h3/Y NAND_u3/A 0.10237f
C1237 XOR_h3/Y OR_k3/B 0.58893f
C1238 XOR_h3/Y XOR_h0/B 0.05422f
C1239 XOR_h3/Y XOR_h2/B 0.35036f
C1240 XOR_h3/Y XOR_h1/B 0.05854f
C1241 XOR_h3/Y AND_g3/a_242_n201# 0.02678f
C1242 XOR_h3/Y AND_g3/a_329_n201# 0.00277f
C1243 XOR_h3/Y XOR_h3/B 0.27437f
C1244 XOR_f1/a_744_n285# XOR_f1/m1_n59_n770# 0
C1245 XOR_f1/a_744_n285# F1 0.04209f
C1246 XOR_f1/a_744_n285# VDD 0.00224f
C1247 XOR_f1/a_831_164# F1 0.00288f
C1248 XOR_f1/a_831_164# VDD 0.00114f
C1249 XOR_f1/a_1028_164# F1 0.02948f
C1250 XOR_f1/a_1028_164# VDD 0.003f
C1251 XOR_f1/a_1115_n285# F1 0.0013f
C1252 XOR_f1/li_n59_n770# F1 0.01083f
C1253 XOR_f1/li_n59_n770# OR_k1/Y 0.00179f
C1254 XOR_f1/li_n59_n770# VDD 0.01179f
C1255 XOR_f1/m1_n59_n770# F1 0.14547f
C1256 XOR_f1/m1_n59_n770# OR_k1/Y 0.00713f
C1257 XOR_f1/m1_n59_n770# VDD 0.03575f
C1258 F1 OR_k1/a_407_n201# 0.03241f
C1259 F1 OR_k1/a_494_80# 0.00377f
C1260 F1 OR_k1/Y 0.16782f
C1261 F1 F3 0.95486f
C1262 F1 XOR_f2/li_n59_n770# 0
C1263 F1 XOR_f2/m1_n59_n770# 0
C1264 F1 OR_k2/a_407_n201# 0.00453f
C1265 F1 OR_k2/a_494_80# 0
C1266 F1 OR_k2/Y 0.01289f
C1267 F1 OR_k3/Y 0.05013f
C1268 F1 S2 0.06408f
C1269 F1 NAND_v1/A 0.05688f
C1270 F1 OR_gr2/B 0.05569f
C1271 F1 NAND_v2/A 0.05422f
C1272 F1 NAND_a3_3/a_371_n201# 0
C1273 F1 NAND_v3/A 0.03231f
C1274 F1 NAND_v1/a_371_n201# 0
C1275 F1 AND_g1/B 0.26179f
C1276 F1 S0 0.04815f
C1277 F1 NAND_u2/B 0
C1278 F1 NAND_a1_2/a_371_n201# 0
C1279 F1 NAND_u2/A 0.03401f
C1280 F1 VDD 3.07646f
C1281 F1 NAND_u3/A 0.04604f
C1282 F1 G_N 0.40663f
C1283 F1 OR_k1/B 0.11631f
C1284 F1 OR_k2/B 0.05885f
C1285 F1 OR_k3/B 0.05489f
C1286 F1 XOR_h0/B 0.05448f
C1287 F1 OR_cy3/Y 0.00167f
C1288 F1 XOR_h2/B 0.04604f
C1289 F1 AND_g1/a_242_n201# 0.03354f
C1290 F1 AND_g1/a_329_n201# 0
C1291 F1 XOR_h1/B 0.49107f
C1292 F1 XOR_h3/B 0.0561f
C1293 OR_k1/a_407_n201# OR_k1/Y 0.00235f
C1294 OR_k1/a_407_n201# S0 0.00229f
C1295 OR_k1/a_407_n201# NAND_u1/A 0
C1296 OR_k1/a_407_n201# VDD 0
C1297 OR_k1/a_407_n201# XOR_h1/B 0
C1298 OR_k1/Y S0 0
C1299 OR_k1/Y NAND_u1/A 0
C1300 OR_k1/Y VDD 0.01565f
C1301 OR_k1/Y OR_k1/B 0
C1302 XOR_f3/a_744_n285# XOR_f3/m1_n59_n770# 0
C1303 XOR_f3/a_744_n285# F3 0
C1304 XOR_f3/a_744_n285# OR_k3/Y 0.0177f
C1305 XOR_f3/a_744_n285# OR_gr2/B 0
C1306 XOR_f3/a_744_n285# VDD 0
C1307 XOR_f3/a_744_n285# XOR_h2/B 0.00586f
C1308 XOR_f3/a_831_164# OR_k3/Y 0.00104f
C1309 XOR_f3/a_831_164# OR_gr2/B 0
C1310 XOR_f3/a_831_164# XOR_h2/B 0
C1311 XOR_f3/a_1028_164# OR_k3/Y 0.0041f
C1312 XOR_f3/a_1028_164# OR_gr2/B 0
C1313 XOR_f3/a_1028_164# XOR_h2/B 0.00292f
C1314 XOR_f3/a_1115_n285# OR_k3/Y 0.00169f
C1315 XOR_f3/a_1115_n285# XOR_h2/B 0
C1316 XOR_f3/li_n59_n770# OR_k3/Y 0.01004f
C1317 XOR_f3/li_n59_n770# OR_gr2/B 0
C1318 XOR_f3/li_n59_n770# VDD 0.02051f
C1319 XOR_f3/m1_n59_n770# OR_k3/Y 0.15292f
C1320 XOR_f3/m1_n59_n770# OR_gr2/B 0
C1321 XOR_f3/m1_n59_n770# VDD 0.05142f
C1322 F3 F2 0.09555f
C1323 F3 OR_k3/Y 0.08484f
C1324 F3 P_N 0.01457f
C1325 F3 NOR_gg/B 0.06424f
C1326 F3 OR_gr2/B 1.01663f
C1327 F3 AND_eq/a_242_n201# 0
C1328 F3 AEQB 0.00205f
C1329 F3 AND_pc3/a_242_n201# 0.04222f
C1330 F3 AND_pc3/a_329_n201# 0.00181f
C1331 F3 OR_cy3/B 0.1222f
C1332 F3 VDD 0.6546f
C1333 F3 NAND_pg/A 0
C1334 F3 NOR_gg/a_490_80# 0
C1335 F3 G_N 3.85621f
C1336 F3 OR_k3/B 0.25724f
C1337 F3 XOR_h2/B 0.02547f
C1338 F3 XOR_h1/B 0
C1339 F3 XOR_h3/B 0.26695f
C1340 XOR_f2/a_744_n285# XOR_f2/m1_n59_n770# 0
C1341 XOR_f2/a_744_n285# F2 0.02875f
C1342 XOR_f2/a_744_n285# VDD 0
C1343 XOR_f2/a_744_n285# OR_k2/B 0.00761f
C1344 XOR_f2/a_744_n285# XOR_h2/B 0.01473f
C1345 XOR_f2/a_831_164# F2 0.00124f
C1346 XOR_f2/a_831_164# XOR_h2/B 0.0037f
C1347 XOR_f2/a_1028_164# F2 0.01265f
C1348 XOR_f2/a_1028_164# XOR_h2/B 0.02031f
C1349 XOR_f2/a_1115_n285# F2 0
C1350 XOR_f2/a_1115_n285# OR_k2/B 0.00151f
C1351 XOR_f2/li_n59_n770# OR_k2/Y 0.00165f
C1352 XOR_f2/li_n59_n770# VDD 0.01829f
C1353 XOR_f2/li_n59_n770# OR_k2/B 0.01145f
C1354 XOR_f2/li_n59_n770# XOR_h2/B 0.01111f
C1355 XOR_f2/m1_n59_n770# F2 0.00443f
C1356 XOR_f2/m1_n59_n770# OR_k2/Y 0.00437f
C1357 XOR_f2/m1_n59_n770# VDD 0.04154f
C1358 XOR_f2/m1_n59_n770# OR_k2/B 0.14588f
C1359 XOR_f2/m1_n59_n770# XOR_h2/B 0.12355f
C1360 F2 OR_k2/Y 0.00973f
C1361 F2 OR_k3/Y 0.06126f
C1362 F2 OR_gr2/B 0.05749f
C1363 F2 NAND_v3/A 0.06165f
C1364 F2 AND_pc2/a_242_n201# 0.03721f
C1365 F2 AND_pc2/a_329_n201# 0
C1366 F2 OR_cy2/B 0.62233f
C1367 F2 S0 1.20264f
C1368 F2 AND_eq/a_242_n201# 0
C1369 F2 AEQB 0
C1370 F2 VDD 2.22958f
C1371 F2 AND_pp01/a_242_n201# 0.00484f
C1372 F2 AND_pp01/a_329_n201# 0
C1373 F2 NAND_pg/A 0.00803f
C1374 F2 NAND_a1_3/a_371_n201# 0.0018f
C1375 F2 NAND_u3/A 0.15679f
C1376 F2 G_N 0.05432f
C1377 F2 OR_k2/B 0.01885f
C1378 F2 OR_cy2/a_407_n201# 0.00562f
C1379 F2 OR_k3/B 0.07217f
C1380 F2 XOR_h0/B 0.21758f
C1381 F2 XOR_h2/B 0.08779f
C1382 F2 XOR_h1/B 0.06299f
C1383 F2 XOR_h3/B 0.06289f
C1384 OR_k2/a_407_n201# OR_k2/Y 0
C1385 OR_k2/a_407_n201# VDD 0
C1386 OR_k2/a_407_n201# OR_k2/B 0.00107f
C1387 OR_k2/a_407_n201# XOR_h2/B 0.01112f
C1388 OR_k2/a_494_80# XOR_h2/B 0.00204f
C1389 OR_k2/Y NAND_u2/A 0
C1390 OR_k2/Y VDD 0.02055f
C1391 OR_k2/Y OR_k2/B 0.34194f
C1392 OR_k2/Y XOR_h2/B 0.02356f
C1393 OR_k3/a_407_n201# OR_k3/Y 0.03189f
C1394 OR_k3/a_407_n201# VDD 0
C1395 OR_k3/a_407_n201# NAND_u3/A 0.01157f
C1396 OR_k3/a_494_80# OR_k3/Y 0.00339f
C1397 OR_k3/a_494_80# NAND_u3/A 0.00204f
C1398 OR_k3/Y S2 0.00576f
C1399 OR_k3/Y OR_gr2/B 0.02662f
C1400 OR_k3/Y NAND_a3_3/a_371_n201# 0
C1401 OR_k3/Y NAND_v3/A 0.55372f
C1402 OR_k3/Y NAND_v3/a_371_n201# 0
C1403 OR_k3/Y AND_g3/B 0.26374f
C1404 OR_k3/Y VDD 2.75382f
C1405 OR_k3/Y NAND_u3/a_371_n201# 0
C1406 OR_k3/Y OR_p3/B 0.26938f
C1407 OR_k3/Y NAND_u3/A 8.1392f
C1408 OR_k3/Y OR_k3/B 0.16251f
C1409 OR_k3/Y XOR_h0/B 0.06207f
C1410 OR_k3/Y XOR_h2/B 0.07375f
C1411 OR_k3/Y XOR_h1/B 0.05448f
C1412 OR_k3/Y AND_g3/a_242_n201# 0.03354f
C1413 OR_k3/Y AND_g3/a_329_n201# 0
C1414 OR_k3/Y XOR_h3/B 0.1502f
C1415 NAND_pg/a_371_n201# OR_gr2/B 0
C1416 NAND_pg/a_371_n201# NAND_pg/B 0
C1417 NAND_pg/a_371_n201# XOR_h0/B 0
C1418 P_N AND_q1/a_242_n201# 0.03801f
C1419 P_N AND_q1/a_329_n201# 0
C1420 P_N OR_gr1/B 0.60498f
C1421 P_N AND_q2/a_242_n201# 0.00462f
C1422 P_N AND_q2/a_329_n201# 0
C1423 P_N OR_gr2/B 1.169f
C1424 P_N VDD 0.10479f
C1425 P_N NAND_pg/B 0.00218f
C1426 P_N OR_gr1/a_407_n201# 0.00562f
C1427 P_N OR_gr1/Y 0.31333f
C1428 P_N OR_k3/B 0.00548f
C1429 P_N XOR_h0/B 0.02066f
C1430 P_N XOR_h1/B 0.06377f
C1431 P_N XOR_h3/B 0
C1432 NAND_a3_0/a_371_n201# AND_g0/B 0.00277f
C1433 S2 NAND_v0/A 0
C1434 S2 NAND_v1/A 0
C1435 S2 NAND_v2/A 0.54455f
C1436 S2 NAND_v3/A 0
C1437 S2 AND_g0/B 0.66764f
C1438 S2 OR_p0/B 0.31136f
C1439 S2 S0 2.4889f
C1440 S2 NAND_u0/A 0.00562f
C1441 S2 OR_p1/B 0.15188f
C1442 S2 NAND_u1/A 0.45298f
C1443 S2 VDD 1.74991f
C1444 S2 Cn 0
C1445 S2 OR_k0/B 0.60364f
C1446 S2 OR_p3/B 0.12292f
C1447 S2 NAND_u3/A 0.00448f
C1448 S2 OR_cy0/a_407_n201# 0
C1449 S2 OR_k1/B 0.62602f
C1450 S2 OR_k2/B 0.21369f
C1451 S2 XOR_h0/B 0.13117f
C1452 S2 XOR_h2/B 0.11868f
C1453 S2 XOR_h1/B 0.19203f
C1454 NAND_v0/A AND_g0/B 0.72686f
C1455 NAND_v0/A VDD 1.03528f
C1456 AND_q1/a_242_n201# OR_gr1/B 0
C1457 AND_q1/a_242_n201# OR_gr2/B 0.02532f
C1458 AND_q1/a_242_n201# VDD 0
C1459 AND_q1/a_242_n201# XOR_h1/B 0.01116f
C1460 AND_q1/a_329_n201# XOR_h1/B 0
C1461 OR_gr1/B OR_gr2/B 0.07747f
C1462 OR_gr1/B VDD 0.00937f
C1463 OR_gr1/B OR_gr1/a_407_n201# 0.00178f
C1464 OR_gr1/B OR_gr1/Y 0
C1465 OR_gr1/B XOR_h0/B 0
C1466 OR_gr1/B XOR_h1/B 0.02377f
C1467 NAND_v1/A S0 0
C1468 NAND_v1/A NAND_u1/A 0
C1469 NAND_v1/A VDD 0.58871f
C1470 NAND_v1/A OR_k1/B 0
C1471 AND_pc0/a_242_n201# OR_cy0/B 0.0013f
C1472 AND_pc0/a_242_n201# S0 0.0084f
C1473 AND_pc0/a_242_n201# NAND_u1/A 0
C1474 AND_pc0/a_242_n201# VDD 0
C1475 AND_pc0/a_242_n201# XOR_h0/B 0.01195f
C1476 AND_pc0/a_329_n201# OR_cy0/B 0
C1477 AND_pc0/a_329_n201# S0 0.0018f
C1478 OR_cy0/B S0 0.42725f
C1479 OR_cy0/B NAND_u1/A 0.00137f
C1480 OR_cy0/B VDD 0.01075f
C1481 OR_cy0/B OR_k0/B 0.00103f
C1482 OR_cy0/B OR_cy0/a_407_n201# 0.00153f
C1483 OR_cy0/B OR_k1/B 0
C1484 OR_cy0/B XOR_h0/B 0.0317f
C1485 AND_q3/a_242_n201# NOR_gg/B 0.00251f
C1486 AND_q3/a_242_n201# VDD 0.00461f
C1487 AND_q3/a_242_n201# OR_gr2/Y 0.00261f
C1488 AND_q3/a_242_n201# XOR_h2/B 0
C1489 AND_q3/a_329_n201# NOR_gg/B 0
C1490 AND_q3/a_329_n201# VDD 0
C1491 NOR_gg/B VDD 0.03425f
C1492 NOR_gg/B G_N 0.00132f
C1493 NOR_gg/B OR_gr2/Y 0.00133f
C1494 NOR_gg/B XOR_h3/B 0.06663f
C1495 AND_q2/a_242_n201# OR_gr2/B 0.03638f
C1496 AND_q2/a_242_n201# VDD 0.0019f
C1497 AND_q2/a_242_n201# OR_gr1/Y 0.00282f
C1498 AND_q2/a_329_n201# OR_gr2/B 0
C1499 AND_q2/a_329_n201# OR_gr1/Y 0
C1500 OR_gr2/B AND_pc3/a_242_n201# 0.02534f
C1501 OR_gr2/B OR_cy3/B 0.27377f
C1502 OR_gr2/B VDD 3.56118f
C1503 OR_gr2/B AND_pp23/a_242_n201# 0.02645f
C1504 OR_gr2/B NAND_pg/B 0.09659f
C1505 OR_gr2/B AND_pp01/a_242_n201# 0.02344f
C1506 OR_gr2/B NAND_pg/A 0.68199f
C1507 OR_gr2/B OR_gr1/a_407_n201# 0.02905f
C1508 OR_gr2/B OR_gr1/a_494_80# 0.00377f
C1509 OR_gr2/B OR_gr1/Y 0.10863f
C1510 OR_gr2/B OR_gr2/a_407_n201# 0.01334f
C1511 OR_gr2/B OR_gr2/a_494_80# 0.00123f
C1512 OR_gr2/B OR_gr2/Y 0.13632f
C1513 OR_gr2/B OR_k3/B 0.01179f
C1514 OR_gr2/B XOR_h0/B 0.00591f
C1515 OR_gr2/B OR_cy3/a_407_n201# 0.03241f
C1516 OR_gr2/B OR_cy3/a_494_80# 0.00377f
C1517 OR_gr2/B OR_cy3/Y 0.2801f
C1518 OR_gr2/B XOR_h2/B 1.17435f
C1519 OR_gr2/B XOR_h1/B 0.5517f
C1520 OR_gr2/B XOR_h3/B 1.16452f
C1521 NAND_a3_2/a_371_n201# NAND_v2/A 0.00277f
C1522 NAND_a3_2/a_371_n201# S0 0
C1523 NAND_v2/A AND_pc1/a_242_n201# 0.00248f
C1524 NAND_v2/A AND_pc1/a_329_n201# 0
C1525 NAND_v2/A S0 0.09735f
C1526 NAND_v2/A NAND_v2/a_371_n201# 0
C1527 NAND_v2/A AND_g2/B 0.06426f
C1528 NAND_v2/A NAND_u2/a_371_n201# 0.00277f
C1529 NAND_v2/A NAND_u2/B 0.30903f
C1530 NAND_v2/A NAND_a1_2/a_371_n201# 0.00277f
C1531 NAND_v2/A NAND_u2/A 0.46108f
C1532 NAND_v2/A VDD 1.26088f
C1533 NAND_v2/A OR_k1/B 0.06013f
C1534 NAND_v2/A OR_cy1/a_407_n201# 0.0309f
C1535 NAND_v2/A OR_cy1/a_494_80# 0
C1536 NAND_v2/A OR_cy1/B 0.24341f
C1537 NAND_v2/A OR_k2/B 0.0959f
C1538 NAND_v2/A XOR_h0/B 0.05337f
C1539 NAND_v2/A AND_g2/a_242_n201# 0
C1540 NAND_v2/A XOR_h2/B 0
C1541 NAND_v2/A XOR_h1/B 0.12787f
C1542 AND_pc1/a_242_n201# VDD 0
C1543 AND_pc1/a_242_n201# OR_k1/B 0.00204f
C1544 AND_pc1/a_242_n201# OR_cy1/B 0.00101f
C1545 NAND_v3/A VDD 0.58822f
C1546 NAND_v3/A NAND_u3/A 1.21776f
C1547 NAND_v3/A OR_k3/B 0
C1548 NAND_v3/A XOR_h3/B 0.52503f
C1549 AND_pc2/a_242_n201# OR_cy2/B 0
C1550 AND_pc2/a_242_n201# VDD 0
C1551 AND_pc2/a_242_n201# XOR_h0/B 0.00295f
C1552 AND_pc2/a_242_n201# XOR_h2/B 0.01496f
C1553 AND_pc2/a_329_n201# XOR_h0/B 0
C1554 OR_cy2/B VDD 0.01804f
C1555 OR_cy2/B OR_k2/B 0
C1556 OR_cy2/B OR_cy2/a_407_n201# 0.00121f
C1557 OR_cy2/B OR_k3/B 0
C1558 OR_cy2/B XOR_h0/B 0.04428f
C1559 OR_cy2/B XOR_h2/B 0.0246f
C1560 OR_cy2/B XOR_h1/B 0.00141f
C1561 NAND_v1/a_371_n201# AND_g1/B 0
C1562 AND_g1/B NAND_u1/A 0
C1563 AND_g1/B VDD 0.02168f
C1564 AND_g1/B AND_g1/a_242_n201# 0.00222f
C1565 AND_g1/B AND_g1/a_329_n201# 0
C1566 AND_g1/B XOR_h1/B 0.0014f
C1567 NAND_v0/a_371_n201# AND_g0/B 0.00277f
C1568 NAND_v0/a_371_n201# VDD 0
C1569 AND_g0/B NAND_u0/a_371_n201# 0.00277f
C1570 AND_g0/B OR_p0/B 0.31573f
C1571 AND_g0/B NAND_a1_0/a_371_n201# 0.00277f
C1572 AND_g0/B S0 0.87746f
C1573 AND_g0/B NAND_u0/A 0.51808f
C1574 AND_g0/B VDD 0.86089f
C1575 AND_g0/B Cn 0.00167f
C1576 AND_g0/B OR_k0/B 0.43323f
C1577 AND_g0/B AND_g0/a_242_n201# 0.01208f
C1578 AND_g0/B AND_g0/a_329_n201# 0.00149f
C1579 AND_g0/B XOR_h0/B 0.08966f
C1580 NAND_u0/a_371_n201# OR_p0/B 0
C1581 OR_p0/B VDD 0.00925f
C1582 NAND_a1_0/a_371_n201# S0 0
C1583 S0 NAND_u0/A 0
C1584 S0 NAND_a1_1/a_371_n201# 0
C1585 S0 NAND_u1/A 0.08344f
C1586 S0 NAND_u2/A 0
C1587 S0 VDD 1.10293f
C1588 S0 Cn 0.05134f
C1589 S0 OR_k0/B 2.04175f
C1590 S0 NAND_u3/A 0
C1591 S0 OR_cy0/a_407_n201# 0.00362f
C1592 S0 OR_k1/B 1.00776f
C1593 S0 XOR_h0/B 0.03522f
C1594 S0 XOR_h1/B 0.0048f
C1595 NAND_u0/A VDD 0.57335f
C1596 NAND_u0/A OR_k0/B 0
C1597 AND_eq/a_242_n201# AEQB 0
C1598 AND_eq/a_242_n201# VDD 0.00461f
C1599 AND_eq/a_242_n201# G_N 0.01913f
C1600 AND_eq/a_329_n201# VDD 0
C1601 AND_eq/a_329_n201# G_N 0.0018f
C1602 AEQB VDD 0.75113f
C1603 AEQB G_N 2.38761f
C1604 AND_pc3/a_242_n201# OR_cy3/B 0
C1605 AND_pc3/a_242_n201# VDD 0
C1606 AND_pc3/a_242_n201# OR_k3/B 0.00563f
C1607 AND_pc3/a_329_n201# OR_k3/B 0.00149f
C1608 OR_cy3/B VDD 0.01081f
C1609 OR_cy3/B OR_k3/B 0.14401f
C1610 OR_cy3/B OR_cy3/a_407_n201# 0.00447f
C1611 OR_cy3/B OR_cy3/Y 0.00101f
C1612 OR_cy3/B XOR_h3/B 0.02917f
C1613 NAND_v2/a_371_n201# AND_g2/B 0
C1614 AND_g2/B VDD 0.0239f
C1615 AND_g2/B AND_g2/a_242_n201# 0.00248f
C1616 AND_g2/B AND_g2/a_329_n201# 0
C1617 AND_g2/B XOR_h2/B 0.19588f
C1618 OR_p1/B NAND_u1/A 0.30347f
C1619 OR_p1/B VDD 0.01754f
C1620 OR_p1/B XOR_h0/B 0
C1621 NAND_u1/A VDD 8.57738f
C1622 NAND_u1/A OR_k0/B 0.00534f
C1623 NAND_u1/A OR_cy0/a_407_n201# 0
C1624 NAND_u1/A OR_k1/B 0.12478f
C1625 NAND_u1/A XOR_h0/B 4.64667f
C1626 NAND_u1/A AND_g1/a_242_n201# 0
C1627 NAND_u1/A XOR_h1/B 0
C1628 NAND_v3/a_371_n201# AND_g3/B 0
C1629 AND_g3/B VDD 0.0212f
C1630 AND_g3/B NAND_u3/A 0.04875f
C1631 AND_g3/B XOR_h0/B 0.29996f
C1632 AND_g3/B AND_g3/a_242_n201# 0.0016f
C1633 AND_g3/B XOR_h3/B 0.00484f
C1634 NAND_u2/a_371_n201# NAND_u2/B 0
C1635 NAND_u2/a_371_n201# XOR_h1/B 0
C1636 NAND_u2/B NAND_u2/A 0.02503f
C1637 NAND_u2/B VDD 0.02188f
C1638 NAND_u2/B OR_k1/B 0.25621f
C1639 NAND_u2/B XOR_h1/B 0.04997f
C1640 NAND_u2/A VDD 0.53917f
C1641 NAND_u2/A OR_k1/B 0.00564f
C1642 NAND_u2/A OR_k2/B 0
C1643 NAND_u2/A XOR_h1/B 1.22037f
C1644 VDD Cn 0.29604f
C1645 VDD OR_k0/B 0.23329f
C1646 VDD AND_pp23/a_242_n201# 0
C1647 VDD NAND_pg/B 0.0117f
C1648 VDD AND_pp01/a_242_n201# 0
C1649 VDD NAND_pg/A 0.37604f
C1650 VDD OR_p3/B 0.01621f
C1651 VDD NAND_a1_3/a_371_n201# 0
C1652 VDD NAND_u3/A 3.73836f
C1653 VDD NOR_gg/a_490_80# 0
C1654 VDD G_N 0.37197f
C1655 VDD OR_cy0/a_407_n201# 0
C1656 VDD OR_k1/B 0.96568f
C1657 VDD OR_gr1/a_407_n201# 0
C1658 VDD OR_gr1/Y 0.01281f
C1659 VDD OR_cy1/a_407_n201# 0
C1660 VDD OR_cy1/B 0.01181f
C1661 VDD OR_k2/B 0.27551f
C1662 VDD OR_gr2/a_407_n201# 0
C1663 VDD OR_gr2/Y 0.02466f
C1664 VDD OR_cy2/a_407_n201# 0.00135f
C1665 VDD OR_cy2/a_494_80# 0
C1666 VDD OR_k3/B 0.41887f
C1667 VDD AND_g0/a_242_n201# 0
C1668 VDD XOR_h0/B 4.09372f
C1669 VDD OR_cy3/a_407_n201# 0
C1670 VDD OR_cy3/Y 0.01051f
C1671 VDD AND_g2/a_242_n201# 0.0019f
C1672 VDD XOR_h2/B 3.33525f
C1673 VDD AND_g1/a_242_n201# 0
C1674 VDD XOR_h1/B 3.80465f
C1675 VDD AND_g3/a_242_n201# 0
C1676 VDD XOR_h3/B 5.10799f
C1677 Cn OR_k0/B 0
C1678 OR_k0/B XOR_h0/B 0.14167f
C1679 AND_pp23/a_242_n201# NAND_pg/B 0.00115f
C1680 AND_pp23/a_242_n201# NAND_pg/A 0.03986f
C1681 AND_pp23/a_242_n201# OR_k3/B 0
C1682 AND_pp23/a_242_n201# XOR_h3/B 0
C1683 AND_pp23/a_329_n201# NAND_pg/A 0
C1684 AND_pp23/a_329_n201# OR_k3/B 0
C1685 NAND_pg/B NAND_pg/A 0.04141f
C1686 NAND_pg/B OR_k3/B 0.19696f
C1687 NAND_pg/B XOR_h0/B 0.12634f
C1688 NAND_pg/B XOR_h3/B 0
C1689 AND_pp01/a_242_n201# NAND_pg/A 0
C1690 AND_pp01/a_242_n201# OR_k3/B 0
C1691 AND_pp01/a_242_n201# XOR_h3/B 0
C1692 NAND_pg/A OR_k3/B 0.00208f
C1693 NAND_pg/A XOR_h0/B 0
C1694 NAND_u3/a_371_n201# XOR_h2/B 0
C1695 OR_p3/B NAND_u3/A 0.02175f
C1696 OR_p3/B XOR_h2/B 0
C1697 NAND_u3/A OR_k3/B 0.05977f
C1698 NAND_u3/A XOR_h0/B 0.05798f
C1699 NAND_u3/A XOR_h2/B 0.01032f
C1700 NAND_u3/A XOR_h1/B 0.05029f
C1701 NAND_u3/A AND_g3/a_242_n201# 0.01496f
C1702 NAND_u3/A XOR_h3/B 0.07765f
C1703 NOR_gg/a_490_80# XOR_h3/B 0.0017f
C1704 G_N XOR_h3/B 0.01207f
C1705 OR_cy0/a_407_n201# OR_k1/B 0.00172f
C1706 OR_cy0/a_407_n201# XOR_h0/B 0.01221f
C1707 OR_cy0/a_494_80# OR_k1/B 0
C1708 OR_cy0/a_494_80# XOR_h0/B 0.00245f
C1709 OR_k1/B OR_cy1/a_407_n201# 0
C1710 OR_k1/B OR_cy1/B 0.08947f
C1711 OR_k1/B OR_k2/B 0.00227f
C1712 OR_k1/B XOR_h0/B 1.09208f
C1713 OR_k1/B XOR_h1/B 0.18742f
C1714 OR_gr1/a_407_n201# OR_gr1/Y 0.00172f
C1715 OR_gr1/Y XOR_h1/B 0
C1716 OR_cy1/a_407_n201# OR_cy1/B 0.00407f
C1717 OR_cy1/a_407_n201# OR_k2/B 0.00204f
C1718 OR_cy1/a_407_n201# XOR_h1/B 0.00527f
C1719 OR_cy1/a_494_80# OR_k2/B 0
C1720 OR_cy1/a_494_80# XOR_h1/B 0.00144f
C1721 OR_cy1/B OR_k2/B 0.00131f
C1722 OR_cy1/B XOR_h1/B 0.02341f
C1723 OR_k2/B XOR_h0/B 0.00221f
C1724 OR_k2/B XOR_h2/B 0.40629f
C1725 OR_k2/B XOR_h1/B 0.07249f
C1726 OR_gr2/a_407_n201# OR_gr2/Y 0
C1727 OR_gr2/a_407_n201# XOR_h2/B 0.01545f
C1728 OR_gr2/a_494_80# XOR_h2/B 0.00245f
C1729 OR_gr2/Y XOR_h2/B 0.21335f
C1730 OR_cy2/a_407_n201# OR_k3/B 0
C1731 OR_cy2/a_407_n201# XOR_h2/B 0
C1732 OR_cy2/a_407_n201# XOR_h1/B 0.00316f
C1733 OR_cy2/a_494_80# XOR_h2/B 0
C1734 OR_cy2/a_494_80# XOR_h1/B 0
C1735 OR_k3/B XOR_h0/B 1.16135f
C1736 OR_k3/B OR_cy3/a_407_n201# 0
C1737 OR_k3/B OR_cy3/Y 0.00354f
C1738 OR_k3/B XOR_h2/B 0
C1739 OR_k3/B XOR_h1/B 1.21172f
C1740 OR_k3/B XOR_h3/B 0.12199f
C1741 AND_g0/a_242_n201# XOR_h0/B 0.00447f
C1742 AND_g0/a_329_n201# XOR_h0/B 0
C1743 XOR_h0/B XOR_h2/B 0.0569f
C1744 XOR_h0/B AND_g1/a_242_n201# 0
C1745 XOR_h0/B XOR_h1/B 0.47095f
C1746 XOR_h0/B AND_g3/a_242_n201# 0.00223f
C1747 XOR_h0/B AND_g3/a_329_n201# 0
C1748 XOR_h0/B XOR_h3/B 0.06076f
C1749 OR_cy3/a_407_n201# OR_cy3/Y 0
C1750 OR_cy3/a_407_n201# XOR_h3/B 0.00527f
C1751 OR_cy3/a_494_80# XOR_h3/B 0.00144f
C1752 OR_cy3/Y XOR_h3/B 0.01048f
C1753 AND_g2/a_242_n201# XOR_h2/B 0.04321f
C1754 AND_g2/a_329_n201# XOR_h2/B 0.00214f
C1755 XOR_h2/B XOR_h1/B 0.00121f
C1756 AND_g1/a_242_n201# XOR_h1/B 0.00356f
C1757 AND_g1/a_329_n201# XOR_h1/B 0
C1758 XOR_h1/B AND_g3/a_242_n201# 0
C1759 XOR_h1/B XOR_h3/B 0.21865f
C1760 AND_g3/a_242_n201# XOR_h3/B 0.00362f
C1761 AND_g3/a_329_n201# XOR_h3/B 0
C1762 XOR_h3/B VSS 2.39828f
C1763 AND_g3/a_329_n201# VSS 0
C1764 AND_g3/a_242_n201# VSS 0
C1765 XOR_h1/B VSS 2.72099f
C1766 AND_g1/a_242_n201# VSS 0
C1767 XOR_h2/B VSS 2.17373f
C1768 AND_g2/a_329_n201# VSS 0
C1769 AND_g2/a_242_n201# VSS 0.00145f
C1770 OR_cy3/Y VSS 0.2287f
C1771 OR_cy3/a_407_n201# VSS 0
C1772 XOR_h0/B VSS 3.5735f
C1773 AND_g0/a_242_n201# VSS 0
C1774 OR_k3/B VSS 7.62271f
C1775 OR_cy2/a_407_n201# VSS 0
C1776 OR_gr2/Y VSS 0.44862f
C1777 OR_gr2/a_407_n201# VSS 0
C1778 OR_k2/B VSS 4.89021f
C1779 OR_cy1/B VSS 0.37618f
C1780 OR_cy1/a_407_n201# VSS 0
C1781 OR_gr1/Y VSS 0.55509f
C1782 OR_gr1/a_407_n201# VSS 0
C1783 OR_k1/B VSS 6.79031f
C1784 OR_cy0/a_407_n201# VSS 0
C1785 G_N VSS -0.06082f
C1786 NAND_u3/A VSS 1.70222f
C1787 OR_p3/B VSS 0.48666f
C1788 NAND_u3/a_371_n201# VSS 0
C1789 NAND_pg/A VSS 0.43994f
C1790 AND_pp01/a_242_n201# VSS 0
C1791 NAND_pg/B VSS 0.43901f
C1792 AND_pp23/a_242_n201# VSS 0
C1793 OR_k0/B VSS 4.05897f
C1794 Cn VSS 0.37168f
C1795 VDD VSS 0.10566p
C1796 NAND_u2/A VSS 0.38517f
C1797 NAND_u2/B VSS 0.35881f
C1798 AND_g3/B VSS 0.48286f
C1799 NAND_v3/a_371_n201# VSS 0
C1800 NAND_u1/A VSS 0.87771f
C1801 OR_p1/B VSS 0.39202f
C1802 AND_g2/B VSS 0.43892f
C1803 OR_cy3/B VSS 0.35446f
C1804 AND_pc3/a_242_n201# VSS 0
C1805 AEQB VSS 1.93967f
C1806 AND_eq/a_242_n201# VSS 0
C1807 NAND_u0/A VSS 0.44143f
C1808 S0 VSS 7.30064f
C1809 OR_p0/B VSS 0.36033f
C1810 AND_g0/B VSS 7.44884f
C1811 NAND_v0/a_371_n201# VSS 0
C1812 AND_g1/B VSS 0.43086f
C1813 OR_cy2/B VSS 0.39042f
C1814 AND_pc2/a_329_n201# VSS 0
C1815 AND_pc2/a_242_n201# VSS 0
C1816 NAND_v3/A VSS 0.39473f
C1817 AND_pc1/a_242_n201# VSS 0
C1818 NAND_v2/A VSS 2.72794f
C1819 OR_gr2/B VSS 1.75876f
C1820 AND_q2/a_242_n201# VSS 0
C1821 NOR_gg/B VSS 0.57454f
C1822 AND_q3/a_329_n201# VSS 0
C1823 AND_q3/a_242_n201# VSS 0.00358f
C1824 OR_cy0/B VSS 0.40898f
C1825 AND_pc0/a_242_n201# VSS 0
C1826 NAND_v1/A VSS 0.46398f
C1827 OR_gr1/B VSS 0.50453f
C1828 AND_q1/a_329_n201# VSS 0
C1829 AND_q1/a_242_n201# VSS 0
C1830 NAND_v0/A VSS 0.74793f
C1831 S2 VSS 13.77375f
C1832 P_N VSS 1.50388f
C1833 OR_k3/Y VSS 1.8573f
C1834 OR_k3/a_494_80# VSS 0
C1835 OR_k3/a_407_n201# VSS 0.00318f
C1836 OR_k2/Y VSS 0.36001f
C1837 OR_k2/a_407_n201# VSS 0
C1838 F2 VSS 4.53054f
C1839 XOR_f2/m1_n59_n770# VSS 0.04544f
C1840 XOR_f2/li_n59_n770# VSS 0.01824f
C1841 XOR_f2/a_744_n285# VSS 0
C1842 F3 VSS 7.58442f
C1843 XOR_f3/m1_n59_n770# VSS 0.04548f
C1844 XOR_f3/li_n59_n770# VSS 0.01843f
C1845 XOR_f3/a_744_n285# VSS 0
C1846 OR_k1/Y VSS 0.49235f
C1847 OR_k1/a_407_n201# VSS 0
C1848 F1 VSS 3.12821f
C1849 XOR_f1/m1_n59_n770# VSS 0.04108f
C1850 XOR_f1/li_n59_n770# VSS 0.01795f
C1851 XOR_f1/a_744_n285# VSS 0
C1852 XOR_h3/Y VSS 3.16848f
C1853 XOR_h3/m1_n59_n770# VSS 0.04507f
C1854 XOR_h3/li_n59_n770# VSS 0.01822f
C1855 XOR_h3/a_744_n285# VSS 0
C1856 OR_k0/Y VSS 0.42644f
C1857 M VSS 2.88791f
C1858 OR_k0/a_407_n201# VSS 0
C1859 F0 VSS 3.86691f
C1860 XOR_f0/m1_n59_n770# VSS 0.04252f
C1861 XOR_f0/li_n59_n770# VSS 0.01823f
C1862 XOR_f0/a_744_n285# VSS 0
C1863 XOR_h2/Y VSS 0.43332f
C1864 XOR_h2/m1_n59_n770# VSS 0.03348f
C1865 XOR_h2/li_n59_n770# VSS 0.01176f
C1866 XOR_h2/a_744_n285# VSS 0
C1867 Cn4 VSS 1.93021f
C1868 XOR_h1/Y VSS 0.59249f
C1869 XOR_h1/m1_n59_n770# VSS 0.0383f
C1870 XOR_h1/li_n59_n770# VSS 0.01572f
C1871 XOR_h1/a_744_n285# VSS 0
C1872 NAND_u3/B VSS 0.54091f
C1873 NAND_a2_3/a_371_n201# VSS 0
C1874 XOR_h0/Y VSS 0.50099f
C1875 XOR_h0/m1_n59_n770# VSS 0.03347f
C1876 XOR_h0/li_n59_n770# VSS 0.01176f
C1877 XOR_h0/a_744_n285# VSS 0
C1878 OR_p2/Y VSS 4.09472f
C1879 OR_p2/B VSS 0.27334f
C1880 A2 VSS 0.63669f
C1881 OR_p2/a_407_n201# VSS 0
C1882 OR_p3/Y VSS 5.21048f
C1883 A3 VSS 2.06262f
C1884 OR_p3/a_407_n201# VSS 0
C1885 NAND_u0/B VSS 0.39783f
C1886 S1 VSS 12.56916f
C1887 NAND_u1/B VSS 9.75265f
C1888 NAND_a2_1/a_371_n201# VSS 0
C1889 OR_p1/Y VSS 2.74429f
C1890 A1 VSS 0.78672f
C1891 OR_p1/a_407_n201# VSS 0
C1892 NOT_nb3/Y VSS 3.0659f
C1893 B3 VSS 1.61432f
C1894 OR_p0/Y VSS 4.42985f
C1895 A0 VSS 1.00548f
C1896 OR_p0/a_407_n201# VSS 0
C1897 NOT_nb2/Y VSS 1.51619f
C1898 B2 VSS 2.5296f
C1899 NAND_v2/B VSS 2.195f
C1900 NAND_a4_2/a_371_n201# VSS 0
C1901 NAND_v3/B VSS 0.40847f
C1902 NOT_nb1/Y VSS 6.05159f
C1903 B1 VSS 2.42136f
C1904 NAND_v1/B VSS 0.3186f
C1905 NOT_nb0/Y VSS 1.60124f
C1906 B0 VSS 1.40591f
C1907 NAND_v0/B VSS 0.57187f
C1908 S3 VSS 7.3764f
C1909 NAND_a4_0/a_371_n201# VSS 0
C1910 AND_eq/A VSS 0.62107f
C1911 AND_e01/a_242_n201# VSS 0
C1912 AND_eq/B VSS 0.39334f
C1913 AND_e23/a_242_n201# VSS 0
.ends

XDUT A0 A1 A2 A3 B0 B1 B2 B3 S0 S1 S2 S3 M Cn F0 F1 F2 F3 AEQB P_N G_N Cn4 VDD VSS ALU181
VDD VDD 0 1.8
VSS VSS 0 0
VA0 A0 0 PWL(0 1.8 4e-09 1.8 4.05e-09 0 8e-09 0 8.05e-09 0 1.2e-08 0 1.205e-08 0 1.6e-08 0 1.605e-08 0 2e-08 0 2.005e-08 1.8 2.4e-08 1.8 2.405e-08 1.8 2.8e-08 1.8 2.805e-08 1.8 3.2e-08 1.8 3.205e-08 1.8 3.6e-08 1.8 3.605e-08 1.8 4e-08 1.8 4.005e-08 0 4.4e-08 0 4.405e-08 0 4.8e-08 0 4.805e-08 0 5.2e-08 0 5.205e-08 0 5.6e-08 0 5.605e-08 1.8 6e-08 1.8 6.005e-08 1.8 6.4e-08 1.8 6.405e-08 0 6.8e-08 0 6.805e-08 0 7.2e-08 0 7.205e-08 1.8 7.6e-08 1.8 7.605e-08 1.8 8e-08 1.8 8.005e-08 0 8.4e-08 0 8.405e-08 0 8.8e-08 0 8.805e-08 1.8 9.2e-08 1.8 9.205e-08 0 9.6e-08 0 9.605e-08 1.8 1e-07 1.8 1.001e-07 1.8 1.04e-07 1.8 1.041e-07 1.8 1.08e-07 1.8 1.081e-07 0 1.12e-07 0 1.121e-07 1.8 1.16e-07 1.8 1.161e-07 1.8 1.2e-07 1.8 1.201e-07 0 1.24e-07 0 1.241e-07 0 1.28e-07 0 1.281e-07 0 1.32e-07 0 1.321e-07 0 1.36e-07 0 1.361e-07 1.8 1.4e-07 1.8 1.401e-07 1.8 1.44e-07 1.8 1.441e-07 1.8 1.48e-07 1.8 1.481e-07 1.8 1.52e-07 1.8 1.521e-07 0 1.56e-07 0 1.561e-07 0 1.6e-07 0 1.601e-07 0 1.64e-07 0 1.641e-07 1.8 1.68e-07 1.8 1.681e-07 1.8 1.72e-07 1.8 1.721e-07 0 1.76e-07 0 1.761e-07 0 1.8e-07 0 1.801e-07 1.8 1.84e-07 1.8 1.841e-07 0 1.88e-07 0 1.881e-07 0 1.92e-07 0 1.921e-07 1.8 1.96e-07 1.8 1.961e-07 0 2e-07 0 2.001e-07 1.8 2.04e-07 1.8 2.041e-07 0 2.08e-07 0 2.081e-07 1.8 2.12e-07 1.8 2.121e-07 0 2.16e-07 0 2.161e-07 1.8 2.2e-07 1.8 2.201e-07 0 2.24e-07 0 2.241e-07 0 2.28e-07 0 2.281e-07 0 2.32e-07 0 2.321e-07 0 2.36e-07 0 2.361e-07 0 2.4e-07 0 2.401e-07 0 2.44e-07 0 2.441e-07 1.8 2.48e-07 1.8 2.481e-07 0 2.52e-07 0 2.521e-07 0 2.56e-07 0 2.561e-07 0 2.6e-07 0 2.601e-07 0 2.64e-07 0 2.641e-07 1.8 2.68e-07 1.8 2.681e-07 1.8 2.72e-07 1.8 2.721e-07 0 2.76e-07 0 2.761e-07 0 2.8e-07 0 2.801e-07 1.8 2.84e-07 1.8 2.841e-07 1.8 2.88e-07 1.8 2.881e-07 0 2.92e-07 0 2.921e-07 1.8 2.96e-07 1.8 2.961e-07 0 3e-07 0 3.001e-07 0 3.04e-07 0 3.041e-07 1.8 3.08e-07 1.8 3.081e-07 0 3.12e-07 0 3.121e-07 0 3.16e-07 0 3.161e-07 1.8 3.2e-07 1.8 3.201e-07 0 3.24e-07 0 3.241e-07 1.8 3.28e-07 1.8 3.281e-07 0 3.32e-07 0 3.321e-07 0 3.36e-07 0 3.361e-07 1.8 3.4e-07 1.8 3.401e-07 0 3.44e-07 0 3.441e-07 0 3.48e-07 0 3.481e-07 0 3.52e-07 0 3.521e-07 0 3.56e-07 0 3.561e-07 1.8 3.6e-07 1.8 3.601e-07 1.8 3.64e-07 1.8 3.641e-07 0 3.68e-07 0 3.681e-07 1.8 3.72e-07 1.8 3.721e-07 1.8 3.76e-07 1.8 3.761e-07 0 3.8e-07 0 3.801e-07 0 3.84e-07 0 3.841e-07 0 3.88e-07 0 3.881e-07 1.8 3.92e-07 1.8 3.921e-07 0 3.96e-07 0 3.961e-07 1.8 4e-07 1.8 4.001e-07 0 4.04e-07 0 4.041e-07 1.8 4.08e-07 1.8 4.081e-07 1.8 4.12e-07 1.8 4.121e-07 1.8 4.16e-07 1.8 4.161e-07 0 4.2e-07 0 4.201e-07 1.8 4.24e-07 1.8 4.241e-07 0 4.28e-07 0 4.281e-07 0 4.32e-07 0 4.321e-07 1.8 4.36e-07 1.8 4.361e-07 1.8 4.4e-07 1.8 4.401e-07 0 4.44e-07 0 4.441e-07 0 4.48e-07 0 4.481e-07 1.8 4.52e-07 1.8 4.521e-07 1.8 4.56e-07 1.8 4.561e-07 0 4.6e-07 0 4.601e-07 0 4.64e-07 0 4.641e-07 1.8 4.68e-07 1.8 4.681e-07 0 4.72e-07 0 4.721e-07 1.8 4.76e-07 1.8 4.761e-07 1.8 4.8e-07 1.8 4.801e-07 0 4.84e-07 0 4.841e-07 1.8 4.88e-07 1.8 4.881e-07 1.8 4.92e-07 1.8 4.921e-07 1.8 4.96e-07 1.8 4.96e-07 1.8 5e-07 1.8 5.001e-07 0 5.04e-07 0 5.041e-07 0 5.08e-07 0 5.081e-07 1.8 5.12e-07 1.8 5.121e-07 1.8 5.16e-07 1.8 5.161e-07 1.8 5.2e-07 1.8 5.201e-07 0 5.24e-07 0 5.24e-07 1.8 5.28e-07 1.8 5.281e-07 0 5.32e-07 0 5.321e-07 0 5.36e-07 0 5.361e-07 0 5.4e-07 0 5.401e-07 0 5.44e-07 0 5.441e-07 1.8 5.48e-07 1.8 5.48e-07 1.8 5.52e-07 1.8 5.521e-07 1.8 5.56e-07 1.8 5.561e-07 1.8 5.6e-07 1.8 5.601e-07 0 5.64e-07 0 5.641e-07 0 5.68e-07 0 5.681e-07 1.8 5.72e-07 1.8 5.72e-07 0 5.76e-07 0 5.761e-07 1.8 5.8e-07 1.8 5.801e-07 1.8 5.84e-07 1.8 5.841e-07 1.8 5.88e-07 1.8 5.881e-07 0 5.92e-07 0 5.921e-07 0 5.96e-07 0 5.96e-07 0 6e-07 0 6.001e-07 1.8 6.04e-07 1.8 6.041e-07 0 6.08e-07 0 6.081e-07 0 6.12e-07 0 6.121e-07 1.8 6.16e-07 1.8 6.161e-07 1.8 6.2e-07 1.8 6.2e-07 1.8 6.24e-07 1.8 6.241e-07 0 6.28e-07 0 6.281e-07 0 6.32e-07 0 6.321e-07 1.8 6.36e-07 1.8 6.361e-07 1.8 6.4e-07 1.8 6.401e-07 1.8 6.44e-07 1.8 6.441e-07 0 6.48e-07 0 6.481e-07 0 6.52e-07 0 6.521e-07 1.8 6.56e-07 1.8 6.561e-07 1.8 6.6e-07 1.8 6.601e-07 0 6.64e-07 0 6.641e-07 0 6.68e-07 0 6.681e-07 0 6.72e-07 0 6.721e-07 1.8 6.76e-07 1.8 6.761e-07 1.8 6.8e-07 1.8 6.801e-07 0 6.84e-07 0 6.841e-07 0 6.88e-07 0 6.881e-07 1.8 6.92e-07 1.8 6.921e-07 1.8 6.96e-07 1.8 6.961e-07 0 7e-07 0 7.001e-07 0 7.04e-07 0 7.041e-07 0 7.08e-07 0 7.081e-07 0 7.12e-07 0 7.121e-07 0 7.16e-07 0 7.161e-07 0 7.2e-07 0 7.201e-07 0 7.24e-07 0 7.241e-07 1.8 7.28e-07 1.8 7.281e-07 0 7.32e-07 0 7.321e-07 1.8 7.36e-07 1.8 7.361e-07 0 7.4e-07 0 7.401e-07 0 7.44e-07 0 7.441e-07 1.8 7.48e-07 1.8 7.481e-07 1.8 7.52e-07 1.8 7.521e-07 0 7.56e-07 0 7.561e-07 1.8 7.6e-07 1.8 7.601e-07 1.8 7.64e-07 1.8 7.641e-07 0 7.68e-07 0 7.681e-07 1.8 7.72e-07 1.8 7.721e-07 0 7.76e-07 0 7.761e-07 1.8 7.8e-07 1.8 7.801e-07 0 7.84e-07 0 7.841e-07 0 7.88e-07 0 7.881e-07 0 7.92e-07 0 7.921e-07 1.8 7.96e-07 1.8 7.961e-07 0 8e-07 0 8.001e-07 0 8.04e-07 0 8.041e-07 0 8.08e-07 0 8.081e-07 1.8 8.12e-07 1.8 8.121e-07 0 8.16e-07 0 8.161e-07 1.8 8.2e-07 1.8 8.201e-07 0 8.24e-07 0 8.241e-07 0 8.28e-07 0 8.281e-07 1.8 8.32e-07 1.8 8.321e-07 1.8 8.36e-07 1.8 8.361e-07 1.8 8.4e-07 1.8 8.401e-07 1.8 8.44e-07 1.8 8.441e-07 1.8 8.48e-07 1.8 8.481e-07 1.8 8.52e-07 1.8 8.521e-07 0 8.56e-07 0 8.561e-07 1.8 8.6e-07 1.8 8.601e-07 1.8 8.64e-07 1.8 8.641e-07 0 8.68e-07 0 8.681e-07 0 8.72e-07 0 8.721e-07 0 8.76e-07 0 8.761e-07 0 8.8e-07 0 8.801e-07 0 8.84e-07 0 8.841e-07 0 8.88e-07 0 8.881e-07 1.8 8.92e-07 1.8 8.921e-07 1.8 8.96e-07 1.8 8.961e-07 0 9e-07 0 9.001e-07 0 9.04e-07 0 9.041e-07 1.8 9.08e-07 1.8 9.081e-07 1.8 9.12e-07 1.8 9.121e-07 1.8 9.16e-07 1.8 9.161e-07 0 9.2e-07 0 9.201e-07 0 9.24e-07 0 9.241e-07 1.8 9.28e-07 1.8 9.281e-07 1.8 9.32e-07 1.8 9.321e-07 0 9.36e-07 0 9.361e-07 0 9.4e-07 0 9.401e-07 1.8 9.44e-07 1.8 9.441e-07 1.8 9.48e-07 1.8 9.481e-07 1.8 9.52e-07 1.8 9.521e-07 1.8 9.56e-07 1.8 9.56e-07 0 9.6e-07 0 9.601e-07 1.8 9.64e-07 1.8 9.64e-07 0 9.68e-07 0 9.68e-07 0 9.72e-07 0 9.72e-07 1.8 9.76e-07 1.8 9.76e-07 1.8 9.8e-07 1.8 9.801e-07 1.8 9.84e-07 1.8 9.84e-07 1.8 9.88e-07 1.8 9.881e-07 0 9.92e-07 0 9.92e-07 0 9.96e-07 0 9.96e-07 1.8 1e-06 1.8 1e-06 1.8 1.004e-06 1.8 1.004e-06 1.8 1.008e-06 1.8 1.008e-06 0 1.012e-06 0 1.012e-06 1.8 1.016e-06 1.8 1.016e-06 0 1.02e-06 0 1.02e-06 0 1.024e-06 0 1.024e-06 1.8 1.028e-06 1.8 1.028e-06 1.8 1.032e-06 1.8 1.032e-06 1.8 1.036e-06 1.8 1.036e-06 1.8)
VA1 A1 0 PWL(0 1.8 4e-09 1.8 4.05e-09 1.8 8e-09 1.8 8.05e-09 1.8 1.2e-08 1.8 1.205e-08 1.8 1.6e-08 1.8 1.605e-08 1.8 2e-08 1.8 2.005e-08 1.8 2.4e-08 1.8 2.405e-08 1.8 2.8e-08 1.8 2.805e-08 0 3.2e-08 0 3.205e-08 1.8 3.6e-08 1.8 3.605e-08 0 4e-08 0 4.005e-08 0 4.4e-08 0 4.405e-08 0 4.8e-08 0 4.805e-08 1.8 5.2e-08 1.8 5.205e-08 1.8 5.6e-08 1.8 5.605e-08 1.8 6e-08 1.8 6.005e-08 1.8 6.4e-08 1.8 6.405e-08 0 6.8e-08 0 6.805e-08 0 7.2e-08 0 7.205e-08 1.8 7.6e-08 1.8 7.605e-08 1.8 8e-08 1.8 8.005e-08 1.8 8.4e-08 1.8 8.405e-08 1.8 8.8e-08 1.8 8.805e-08 0 9.2e-08 0 9.205e-08 1.8 9.6e-08 1.8 9.605e-08 0 1e-07 0 1.001e-07 0 1.04e-07 0 1.041e-07 0 1.08e-07 0 1.081e-07 0 1.12e-07 0 1.121e-07 1.8 1.16e-07 1.8 1.161e-07 0 1.2e-07 0 1.201e-07 0 1.24e-07 0 1.241e-07 0 1.28e-07 0 1.281e-07 0 1.32e-07 0 1.321e-07 1.8 1.36e-07 1.8 1.361e-07 0 1.4e-07 0 1.401e-07 0 1.44e-07 0 1.441e-07 0 1.48e-07 0 1.481e-07 1.8 1.52e-07 1.8 1.521e-07 0 1.56e-07 0 1.561e-07 1.8 1.6e-07 1.8 1.601e-07 1.8 1.64e-07 1.8 1.641e-07 0 1.68e-07 0 1.681e-07 0 1.72e-07 0 1.721e-07 1.8 1.76e-07 1.8 1.761e-07 0 1.8e-07 0 1.801e-07 1.8 1.84e-07 1.8 1.841e-07 1.8 1.88e-07 1.8 1.881e-07 1.8 1.92e-07 1.8 1.921e-07 0 1.96e-07 0 1.961e-07 0 2e-07 0 2.001e-07 1.8 2.04e-07 1.8 2.041e-07 1.8 2.08e-07 1.8 2.081e-07 1.8 2.12e-07 1.8 2.121e-07 1.8 2.16e-07 1.8 2.161e-07 1.8 2.2e-07 1.8 2.201e-07 0 2.24e-07 0 2.241e-07 0 2.28e-07 0 2.281e-07 0 2.32e-07 0 2.321e-07 1.8 2.36e-07 1.8 2.361e-07 1.8 2.4e-07 1.8 2.401e-07 0 2.44e-07 0 2.441e-07 0 2.48e-07 0 2.481e-07 1.8 2.52e-07 1.8 2.521e-07 0 2.56e-07 0 2.561e-07 0 2.6e-07 0 2.601e-07 0 2.64e-07 0 2.641e-07 0 2.68e-07 0 2.681e-07 0 2.72e-07 0 2.721e-07 1.8 2.76e-07 1.8 2.761e-07 1.8 2.8e-07 1.8 2.801e-07 0 2.84e-07 0 2.841e-07 1.8 2.88e-07 1.8 2.881e-07 1.8 2.92e-07 1.8 2.921e-07 1.8 2.96e-07 1.8 2.961e-07 0 3e-07 0 3.001e-07 1.8 3.04e-07 1.8 3.041e-07 0 3.08e-07 0 3.081e-07 1.8 3.12e-07 1.8 3.121e-07 0 3.16e-07 0 3.161e-07 0 3.2e-07 0 3.201e-07 0 3.24e-07 0 3.241e-07 1.8 3.28e-07 1.8 3.281e-07 0 3.32e-07 0 3.321e-07 1.8 3.36e-07 1.8 3.361e-07 0 3.4e-07 0 3.401e-07 0 3.44e-07 0 3.441e-07 0 3.48e-07 0 3.481e-07 0 3.52e-07 0 3.521e-07 1.8 3.56e-07 1.8 3.561e-07 1.8 3.6e-07 1.8 3.601e-07 1.8 3.64e-07 1.8 3.641e-07 0 3.68e-07 0 3.681e-07 1.8 3.72e-07 1.8 3.721e-07 0 3.76e-07 0 3.761e-07 1.8 3.8e-07 1.8 3.801e-07 1.8 3.84e-07 1.8 3.841e-07 1.8 3.88e-07 1.8 3.881e-07 0 3.92e-07 0 3.921e-07 1.8 3.96e-07 1.8 3.961e-07 0 4e-07 0 4.001e-07 0 4.04e-07 0 4.041e-07 1.8 4.08e-07 1.8 4.081e-07 1.8 4.12e-07 1.8 4.121e-07 1.8 4.16e-07 1.8 4.161e-07 0 4.2e-07 0 4.201e-07 0 4.24e-07 0 4.241e-07 1.8 4.28e-07 1.8 4.281e-07 1.8 4.32e-07 1.8 4.321e-07 0 4.36e-07 0 4.361e-07 1.8 4.4e-07 1.8 4.401e-07 1.8 4.44e-07 1.8 4.441e-07 1.8 4.48e-07 1.8 4.481e-07 1.8 4.52e-07 1.8 4.521e-07 0 4.56e-07 0 4.561e-07 0 4.6e-07 0 4.601e-07 1.8 4.64e-07 1.8 4.641e-07 0 4.68e-07 0 4.681e-07 1.8 4.72e-07 1.8 4.721e-07 0 4.76e-07 0 4.761e-07 0 4.8e-07 0 4.801e-07 1.8 4.84e-07 1.8 4.841e-07 1.8 4.88e-07 1.8 4.881e-07 1.8 4.92e-07 1.8 4.921e-07 1.8 4.96e-07 1.8 4.96e-07 0 5e-07 0 5.001e-07 1.8 5.04e-07 1.8 5.041e-07 0 5.08e-07 0 5.081e-07 0 5.12e-07 0 5.121e-07 0 5.16e-07 0 5.161e-07 1.8 5.2e-07 1.8 5.201e-07 1.8 5.24e-07 1.8 5.24e-07 0 5.28e-07 0 5.281e-07 0 5.32e-07 0 5.321e-07 1.8 5.36e-07 1.8 5.361e-07 1.8 5.4e-07 1.8 5.401e-07 1.8 5.44e-07 1.8 5.441e-07 1.8 5.48e-07 1.8 5.48e-07 0 5.52e-07 0 5.521e-07 1.8 5.56e-07 1.8 5.561e-07 1.8 5.6e-07 1.8 5.601e-07 0 5.64e-07 0 5.641e-07 1.8 5.68e-07 1.8 5.681e-07 1.8 5.72e-07 1.8 5.72e-07 1.8 5.76e-07 1.8 5.761e-07 1.8 5.8e-07 1.8 5.801e-07 1.8 5.84e-07 1.8 5.841e-07 1.8 5.88e-07 1.8 5.881e-07 0 5.92e-07 0 5.921e-07 0 5.96e-07 0 5.96e-07 0 6e-07 0 6.001e-07 1.8 6.04e-07 1.8 6.041e-07 1.8 6.08e-07 1.8 6.081e-07 1.8 6.12e-07 1.8 6.121e-07 0 6.16e-07 0 6.161e-07 1.8 6.2e-07 1.8 6.2e-07 1.8 6.24e-07 1.8 6.241e-07 0 6.28e-07 0 6.281e-07 1.8 6.32e-07 1.8 6.321e-07 1.8 6.36e-07 1.8 6.361e-07 0 6.4e-07 0 6.401e-07 1.8 6.44e-07 1.8 6.441e-07 0 6.48e-07 0 6.481e-07 0 6.52e-07 0 6.521e-07 0 6.56e-07 0 6.561e-07 1.8 6.6e-07 1.8 6.601e-07 1.8 6.64e-07 1.8 6.641e-07 0 6.68e-07 0 6.681e-07 0 6.72e-07 0 6.721e-07 0 6.76e-07 0 6.761e-07 0 6.8e-07 0 6.801e-07 1.8 6.84e-07 1.8 6.841e-07 1.8 6.88e-07 1.8 6.881e-07 0 6.92e-07 0 6.921e-07 1.8 6.96e-07 1.8 6.961e-07 0 7e-07 0 7.001e-07 1.8 7.04e-07 1.8 7.041e-07 0 7.08e-07 0 7.081e-07 0 7.12e-07 0 7.121e-07 1.8 7.16e-07 1.8 7.161e-07 1.8 7.2e-07 1.8 7.201e-07 0 7.24e-07 0 7.241e-07 0 7.28e-07 0 7.281e-07 0 7.32e-07 0 7.321e-07 0 7.36e-07 0 7.361e-07 0 7.4e-07 0 7.401e-07 1.8 7.44e-07 1.8 7.441e-07 1.8 7.48e-07 1.8 7.481e-07 0 7.52e-07 0 7.521e-07 1.8 7.56e-07 1.8 7.561e-07 0 7.6e-07 0 7.601e-07 1.8 7.64e-07 1.8 7.641e-07 1.8 7.68e-07 1.8 7.681e-07 1.8 7.72e-07 1.8 7.721e-07 0 7.76e-07 0 7.761e-07 1.8 7.8e-07 1.8 7.801e-07 1.8 7.84e-07 1.8 7.841e-07 0 7.88e-07 0 7.881e-07 1.8 7.92e-07 1.8 7.921e-07 1.8 7.96e-07 1.8 7.961e-07 1.8 8e-07 1.8 8.001e-07 1.8 8.04e-07 1.8 8.041e-07 0 8.08e-07 0 8.081e-07 0 8.12e-07 0 8.121e-07 1.8 8.16e-07 1.8 8.161e-07 0 8.2e-07 0 8.201e-07 0 8.24e-07 0 8.241e-07 0 8.28e-07 0 8.281e-07 0 8.32e-07 0 8.321e-07 1.8 8.36e-07 1.8 8.361e-07 0 8.4e-07 0 8.401e-07 1.8 8.44e-07 1.8 8.441e-07 1.8 8.48e-07 1.8 8.481e-07 1.8 8.52e-07 1.8 8.521e-07 0 8.56e-07 0 8.561e-07 1.8 8.6e-07 1.8 8.601e-07 0 8.64e-07 0 8.641e-07 0 8.68e-07 0 8.681e-07 1.8 8.72e-07 1.8 8.721e-07 0 8.76e-07 0 8.761e-07 0 8.8e-07 0 8.801e-07 0 8.84e-07 0 8.841e-07 0 8.88e-07 0 8.881e-07 1.8 8.92e-07 1.8 8.921e-07 0 8.96e-07 0 8.961e-07 0 9e-07 0 9.001e-07 0 9.04e-07 0 9.041e-07 1.8 9.08e-07 1.8 9.081e-07 0 9.12e-07 0 9.121e-07 0 9.16e-07 0 9.161e-07 0 9.2e-07 0 9.201e-07 0 9.24e-07 0 9.241e-07 0 9.28e-07 0 9.281e-07 0 9.32e-07 0 9.321e-07 1.8 9.36e-07 1.8 9.361e-07 1.8 9.4e-07 1.8 9.401e-07 0 9.44e-07 0 9.441e-07 1.8 9.48e-07 1.8 9.481e-07 0 9.52e-07 0 9.521e-07 0 9.56e-07 0 9.56e-07 1.8 9.6e-07 1.8 9.601e-07 1.8 9.64e-07 1.8 9.64e-07 0 9.68e-07 0 9.68e-07 0 9.72e-07 0 9.72e-07 0 9.76e-07 0 9.76e-07 0 9.8e-07 0 9.801e-07 0 9.84e-07 0 9.84e-07 1.8 9.88e-07 1.8 9.881e-07 0 9.92e-07 0 9.92e-07 0 9.96e-07 0 9.96e-07 1.8 1e-06 1.8 1e-06 1.8 1.004e-06 1.8 1.004e-06 1.8 1.008e-06 1.8 1.008e-06 0 1.012e-06 0 1.012e-06 0 1.016e-06 0 1.016e-06 0 1.02e-06 0 1.02e-06 1.8 1.024e-06 1.8 1.024e-06 1.8 1.028e-06 1.8 1.028e-06 1.8 1.032e-06 1.8 1.032e-06 1.8 1.036e-06 1.8 1.036e-06 1.8)
VA2 A2 0 PWL(0 0 4e-09 0 4.05e-09 0 8e-09 0 8.05e-09 1.8 1.2e-08 1.8 1.205e-08 0 1.6e-08 0 1.605e-08 1.8 2e-08 1.8 2.005e-08 1.8 2.4e-08 1.8 2.405e-08 1.8 2.8e-08 1.8 2.805e-08 0 3.2e-08 0 3.205e-08 0 3.6e-08 0 3.605e-08 0 4e-08 0 4.005e-08 1.8 4.4e-08 1.8 4.405e-08 1.8 4.8e-08 1.8 4.805e-08 1.8 5.2e-08 1.8 5.205e-08 1.8 5.6e-08 1.8 5.605e-08 0 6e-08 0 6.005e-08 1.8 6.4e-08 1.8 6.405e-08 1.8 6.8e-08 1.8 6.805e-08 1.8 7.2e-08 1.8 7.205e-08 1.8 7.6e-08 1.8 7.605e-08 1.8 8e-08 1.8 8.005e-08 0 8.4e-08 0 8.405e-08 0 8.8e-08 0 8.805e-08 1.8 9.2e-08 1.8 9.205e-08 0 9.6e-08 0 9.605e-08 1.8 1e-07 1.8 1.001e-07 0 1.04e-07 0 1.041e-07 0 1.08e-07 0 1.081e-07 1.8 1.12e-07 1.8 1.121e-07 0 1.16e-07 0 1.161e-07 1.8 1.2e-07 1.8 1.201e-07 0 1.24e-07 0 1.241e-07 0 1.28e-07 0 1.281e-07 1.8 1.32e-07 1.8 1.321e-07 0 1.36e-07 0 1.361e-07 0 1.4e-07 0 1.401e-07 0 1.44e-07 0 1.441e-07 0 1.48e-07 0 1.481e-07 0 1.52e-07 0 1.521e-07 0 1.56e-07 0 1.561e-07 1.8 1.6e-07 1.8 1.601e-07 0 1.64e-07 0 1.641e-07 1.8 1.68e-07 1.8 1.681e-07 0 1.72e-07 0 1.721e-07 0 1.76e-07 0 1.761e-07 0 1.8e-07 0 1.801e-07 1.8 1.84e-07 1.8 1.841e-07 1.8 1.88e-07 1.8 1.881e-07 1.8 1.92e-07 1.8 1.921e-07 1.8 1.96e-07 1.8 1.961e-07 1.8 2e-07 1.8 2.001e-07 1.8 2.04e-07 1.8 2.041e-07 1.8 2.08e-07 1.8 2.081e-07 0 2.12e-07 0 2.121e-07 1.8 2.16e-07 1.8 2.161e-07 1.8 2.2e-07 1.8 2.201e-07 1.8 2.24e-07 1.8 2.241e-07 0 2.28e-07 0 2.281e-07 0 2.32e-07 0 2.321e-07 0 2.36e-07 0 2.361e-07 0 2.4e-07 0 2.401e-07 1.8 2.44e-07 1.8 2.441e-07 1.8 2.48e-07 1.8 2.481e-07 1.8 2.52e-07 1.8 2.521e-07 0 2.56e-07 0 2.561e-07 1.8 2.6e-07 1.8 2.601e-07 0 2.64e-07 0 2.641e-07 0 2.68e-07 0 2.681e-07 1.8 2.72e-07 1.8 2.721e-07 1.8 2.76e-07 1.8 2.761e-07 0 2.8e-07 0 2.801e-07 0 2.84e-07 0 2.841e-07 1.8 2.88e-07 1.8 2.881e-07 1.8 2.92e-07 1.8 2.921e-07 1.8 2.96e-07 1.8 2.961e-07 1.8 3e-07 1.8 3.001e-07 0 3.04e-07 0 3.041e-07 0 3.08e-07 0 3.081e-07 0 3.12e-07 0 3.121e-07 1.8 3.16e-07 1.8 3.161e-07 0 3.2e-07 0 3.201e-07 0 3.24e-07 0 3.241e-07 0 3.28e-07 0 3.281e-07 1.8 3.32e-07 1.8 3.321e-07 0 3.36e-07 0 3.361e-07 1.8 3.4e-07 1.8 3.401e-07 1.8 3.44e-07 1.8 3.441e-07 1.8 3.48e-07 1.8 3.481e-07 0 3.52e-07 0 3.521e-07 0 3.56e-07 0 3.561e-07 0 3.6e-07 0 3.601e-07 1.8 3.64e-07 1.8 3.641e-07 0 3.68e-07 0 3.681e-07 0 3.72e-07 0 3.721e-07 0 3.76e-07 0 3.761e-07 0 3.8e-07 0 3.801e-07 0 3.84e-07 0 3.841e-07 0 3.88e-07 0 3.881e-07 1.8 3.92e-07 1.8 3.921e-07 1.8 3.96e-07 1.8 3.961e-07 0 4e-07 0 4.001e-07 1.8 4.04e-07 1.8 4.041e-07 1.8 4.08e-07 1.8 4.081e-07 0 4.12e-07 0 4.121e-07 1.8 4.16e-07 1.8 4.161e-07 1.8 4.2e-07 1.8 4.201e-07 1.8 4.24e-07 1.8 4.241e-07 0 4.28e-07 0 4.281e-07 0 4.32e-07 0 4.321e-07 0 4.36e-07 0 4.361e-07 0 4.4e-07 0 4.401e-07 0 4.44e-07 0 4.441e-07 1.8 4.48e-07 1.8 4.481e-07 1.8 4.52e-07 1.8 4.521e-07 1.8 4.56e-07 1.8 4.561e-07 1.8 4.6e-07 1.8 4.601e-07 1.8 4.64e-07 1.8 4.641e-07 1.8 4.68e-07 1.8 4.681e-07 1.8 4.72e-07 1.8 4.721e-07 0 4.76e-07 0 4.761e-07 1.8 4.8e-07 1.8 4.801e-07 0 4.84e-07 0 4.841e-07 0 4.88e-07 0 4.881e-07 0 4.92e-07 0 4.921e-07 1.8 4.96e-07 1.8 4.96e-07 1.8 5e-07 1.8 5.001e-07 0 5.04e-07 0 5.041e-07 0 5.08e-07 0 5.081e-07 0 5.12e-07 0 5.121e-07 0 5.16e-07 0 5.161e-07 1.8 5.2e-07 1.8 5.201e-07 1.8 5.24e-07 1.8 5.24e-07 1.8 5.28e-07 1.8 5.281e-07 0 5.32e-07 0 5.321e-07 0 5.36e-07 0 5.361e-07 0 5.4e-07 0 5.401e-07 0 5.44e-07 0 5.441e-07 0 5.48e-07 0 5.48e-07 0 5.52e-07 0 5.521e-07 1.8 5.56e-07 1.8 5.561e-07 1.8 5.6e-07 1.8 5.601e-07 1.8 5.64e-07 1.8 5.641e-07 0 5.68e-07 0 5.681e-07 0 5.72e-07 0 5.72e-07 0 5.76e-07 0 5.761e-07 0 5.8e-07 0 5.801e-07 0 5.84e-07 0 5.841e-07 1.8 5.88e-07 1.8 5.881e-07 1.8 5.92e-07 1.8 5.921e-07 0 5.96e-07 0 5.96e-07 1.8 6e-07 1.8 6.001e-07 0 6.04e-07 0 6.041e-07 1.8 6.08e-07 1.8 6.081e-07 1.8 6.12e-07 1.8 6.121e-07 0 6.16e-07 0 6.161e-07 0 6.2e-07 0 6.2e-07 1.8 6.24e-07 1.8 6.241e-07 0 6.28e-07 0 6.281e-07 0 6.32e-07 0 6.321e-07 0 6.36e-07 0 6.361e-07 1.8 6.4e-07 1.8 6.401e-07 1.8 6.44e-07 1.8 6.441e-07 1.8 6.48e-07 1.8 6.481e-07 1.8 6.52e-07 1.8 6.521e-07 1.8 6.56e-07 1.8 6.561e-07 1.8 6.6e-07 1.8 6.601e-07 0 6.64e-07 0 6.641e-07 0 6.68e-07 0 6.681e-07 1.8 6.72e-07 1.8 6.721e-07 1.8 6.76e-07 1.8 6.761e-07 0 6.8e-07 0 6.801e-07 1.8 6.84e-07 1.8 6.841e-07 1.8 6.88e-07 1.8 6.881e-07 0 6.92e-07 0 6.921e-07 0 6.96e-07 0 6.961e-07 1.8 7e-07 1.8 7.001e-07 0 7.04e-07 0 7.041e-07 0 7.08e-07 0 7.081e-07 1.8 7.12e-07 1.8 7.121e-07 1.8 7.16e-07 1.8 7.161e-07 0 7.2e-07 0 7.201e-07 1.8 7.24e-07 1.8 7.241e-07 0 7.28e-07 0 7.281e-07 1.8 7.32e-07 1.8 7.321e-07 1.8 7.36e-07 1.8 7.361e-07 1.8 7.4e-07 1.8 7.401e-07 0 7.44e-07 0 7.441e-07 0 7.48e-07 0 7.481e-07 1.8 7.52e-07 1.8 7.521e-07 1.8 7.56e-07 1.8 7.561e-07 1.8 7.6e-07 1.8 7.601e-07 1.8 7.64e-07 1.8 7.641e-07 0 7.68e-07 0 7.681e-07 1.8 7.72e-07 1.8 7.721e-07 0 7.76e-07 0 7.761e-07 0 7.8e-07 0 7.801e-07 1.8 7.84e-07 1.8 7.841e-07 1.8 7.88e-07 1.8 7.881e-07 1.8 7.92e-07 1.8 7.921e-07 0 7.96e-07 0 7.961e-07 1.8 8e-07 1.8 8.001e-07 1.8 8.04e-07 1.8 8.041e-07 0 8.08e-07 0 8.081e-07 1.8 8.12e-07 1.8 8.121e-07 0 8.16e-07 0 8.161e-07 1.8 8.2e-07 1.8 8.201e-07 1.8 8.24e-07 1.8 8.241e-07 0 8.28e-07 0 8.281e-07 0 8.32e-07 0 8.321e-07 1.8 8.36e-07 1.8 8.361e-07 0 8.4e-07 0 8.401e-07 1.8 8.44e-07 1.8 8.441e-07 1.8 8.48e-07 1.8 8.481e-07 0 8.52e-07 0 8.521e-07 0 8.56e-07 0 8.561e-07 1.8 8.6e-07 1.8 8.601e-07 0 8.64e-07 0 8.641e-07 1.8 8.68e-07 1.8 8.681e-07 1.8 8.72e-07 1.8 8.721e-07 1.8 8.76e-07 1.8 8.761e-07 1.8 8.8e-07 1.8 8.801e-07 0 8.84e-07 0 8.841e-07 1.8 8.88e-07 1.8 8.881e-07 1.8 8.92e-07 1.8 8.921e-07 1.8 8.96e-07 1.8 8.961e-07 1.8 9e-07 1.8 9.001e-07 0 9.04e-07 0 9.041e-07 1.8 9.08e-07 1.8 9.081e-07 0 9.12e-07 0 9.121e-07 0 9.16e-07 0 9.161e-07 1.8 9.2e-07 1.8 9.201e-07 1.8 9.24e-07 1.8 9.241e-07 0 9.28e-07 0 9.281e-07 1.8 9.32e-07 1.8 9.321e-07 0 9.36e-07 0 9.361e-07 1.8 9.4e-07 1.8 9.401e-07 0 9.44e-07 0 9.441e-07 0 9.48e-07 0 9.481e-07 1.8 9.52e-07 1.8 9.521e-07 1.8 9.56e-07 1.8 9.56e-07 1.8 9.6e-07 1.8 9.601e-07 1.8 9.64e-07 1.8 9.64e-07 0 9.68e-07 0 9.68e-07 0 9.72e-07 0 9.72e-07 0 9.76e-07 0 9.76e-07 1.8 9.8e-07 1.8 9.801e-07 0 9.84e-07 0 9.84e-07 0 9.88e-07 0 9.881e-07 0 9.92e-07 0 9.92e-07 0 9.96e-07 0 9.96e-07 0 1e-06 0 1e-06 1.8 1.004e-06 1.8 1.004e-06 1.8 1.008e-06 1.8 1.008e-06 1.8 1.012e-06 1.8 1.012e-06 1.8 1.016e-06 1.8 1.016e-06 1.8 1.02e-06 1.8 1.02e-06 1.8 1.024e-06 1.8 1.024e-06 1.8 1.028e-06 1.8 1.028e-06 1.8 1.032e-06 1.8 1.032e-06 1.8 1.036e-06 1.8 1.036e-06 1.8)
VA3 A3 0 PWL(0 0 4e-09 0 4.05e-09 1.8 8e-09 1.8 8.05e-09 0 1.2e-08 0 1.205e-08 1.8 1.6e-08 1.8 1.605e-08 1.8 2e-08 1.8 2.005e-08 0 2.4e-08 0 2.405e-08 0 2.8e-08 0 2.805e-08 0 3.2e-08 0 3.205e-08 1.8 3.6e-08 1.8 3.605e-08 1.8 4e-08 1.8 4.005e-08 1.8 4.4e-08 1.8 4.405e-08 1.8 4.8e-08 1.8 4.805e-08 0 5.2e-08 0 5.205e-08 1.8 5.6e-08 1.8 5.605e-08 0 6e-08 0 6.005e-08 0 6.4e-08 0 6.405e-08 0 6.8e-08 0 6.805e-08 0 7.2e-08 0 7.205e-08 0 7.6e-08 0 7.605e-08 1.8 8e-08 1.8 8.005e-08 0 8.4e-08 0 8.405e-08 1.8 8.8e-08 1.8 8.805e-08 1.8 9.2e-08 1.8 9.205e-08 1.8 9.6e-08 1.8 9.605e-08 0 1e-07 0 1.001e-07 0 1.04e-07 0 1.041e-07 1.8 1.08e-07 1.8 1.081e-07 0 1.12e-07 0 1.121e-07 1.8 1.16e-07 1.8 1.161e-07 1.8 1.2e-07 1.8 1.201e-07 0 1.24e-07 0 1.241e-07 0 1.28e-07 0 1.281e-07 0 1.32e-07 0 1.321e-07 0 1.36e-07 0 1.361e-07 0 1.4e-07 0 1.401e-07 0 1.44e-07 0 1.441e-07 1.8 1.48e-07 1.8 1.481e-07 1.8 1.52e-07 1.8 1.521e-07 0 1.56e-07 0 1.561e-07 1.8 1.6e-07 1.8 1.601e-07 0 1.64e-07 0 1.641e-07 0 1.68e-07 0 1.681e-07 0 1.72e-07 0 1.721e-07 1.8 1.76e-07 1.8 1.761e-07 1.8 1.8e-07 1.8 1.801e-07 1.8 1.84e-07 1.8 1.841e-07 0 1.88e-07 0 1.881e-07 0 1.92e-07 0 1.921e-07 1.8 1.96e-07 1.8 1.961e-07 0 2e-07 0 2.001e-07 1.8 2.04e-07 1.8 2.041e-07 1.8 2.08e-07 1.8 2.081e-07 0 2.12e-07 0 2.121e-07 0 2.16e-07 0 2.161e-07 1.8 2.2e-07 1.8 2.201e-07 0 2.24e-07 0 2.241e-07 1.8 2.28e-07 1.8 2.281e-07 0 2.32e-07 0 2.321e-07 1.8 2.36e-07 1.8 2.361e-07 1.8 2.4e-07 1.8 2.401e-07 0 2.44e-07 0 2.441e-07 1.8 2.48e-07 1.8 2.481e-07 1.8 2.52e-07 1.8 2.521e-07 1.8 2.56e-07 1.8 2.561e-07 1.8 2.6e-07 1.8 2.601e-07 0 2.64e-07 0 2.641e-07 1.8 2.68e-07 1.8 2.681e-07 1.8 2.72e-07 1.8 2.721e-07 1.8 2.76e-07 1.8 2.761e-07 1.8 2.8e-07 1.8 2.801e-07 1.8 2.84e-07 1.8 2.841e-07 1.8 2.88e-07 1.8 2.881e-07 1.8 2.92e-07 1.8 2.921e-07 1.8 2.96e-07 1.8 2.961e-07 1.8 3e-07 1.8 3.001e-07 0 3.04e-07 0 3.041e-07 0 3.08e-07 0 3.081e-07 0 3.12e-07 0 3.121e-07 1.8 3.16e-07 1.8 3.161e-07 0 3.2e-07 0 3.201e-07 1.8 3.24e-07 1.8 3.241e-07 0 3.28e-07 0 3.281e-07 0 3.32e-07 0 3.321e-07 1.8 3.36e-07 1.8 3.361e-07 1.8 3.4e-07 1.8 3.401e-07 1.8 3.44e-07 1.8 3.441e-07 1.8 3.48e-07 1.8 3.481e-07 0 3.52e-07 0 3.521e-07 1.8 3.56e-07 1.8 3.561e-07 1.8 3.6e-07 1.8 3.601e-07 1.8 3.64e-07 1.8 3.641e-07 1.8 3.68e-07 1.8 3.681e-07 1.8 3.72e-07 1.8 3.721e-07 0 3.76e-07 0 3.761e-07 1.8 3.8e-07 1.8 3.801e-07 0 3.84e-07 0 3.841e-07 1.8 3.88e-07 1.8 3.881e-07 0 3.92e-07 0 3.921e-07 1.8 3.96e-07 1.8 3.961e-07 1.8 4e-07 1.8 4.001e-07 1.8 4.04e-07 1.8 4.041e-07 1.8 4.08e-07 1.8 4.081e-07 0 4.12e-07 0 4.121e-07 1.8 4.16e-07 1.8 4.161e-07 1.8 4.2e-07 1.8 4.201e-07 1.8 4.24e-07 1.8 4.241e-07 0 4.28e-07 0 4.281e-07 0 4.32e-07 0 4.321e-07 0 4.36e-07 0 4.361e-07 0 4.4e-07 0 4.401e-07 1.8 4.44e-07 1.8 4.441e-07 0 4.48e-07 0 4.481e-07 0 4.52e-07 0 4.521e-07 1.8 4.56e-07 1.8 4.561e-07 1.8 4.6e-07 1.8 4.601e-07 1.8 4.64e-07 1.8 4.641e-07 0 4.68e-07 0 4.681e-07 1.8 4.72e-07 1.8 4.721e-07 1.8 4.76e-07 1.8 4.761e-07 0 4.8e-07 0 4.801e-07 1.8 4.84e-07 1.8 4.841e-07 1.8 4.88e-07 1.8 4.881e-07 0 4.92e-07 0 4.921e-07 0 4.96e-07 0 4.96e-07 1.8 5e-07 1.8 5.001e-07 1.8 5.04e-07 1.8 5.041e-07 0 5.08e-07 0 5.081e-07 1.8 5.12e-07 1.8 5.121e-07 0 5.16e-07 0 5.161e-07 0 5.2e-07 0 5.201e-07 1.8 5.24e-07 1.8 5.24e-07 1.8 5.28e-07 1.8 5.281e-07 1.8 5.32e-07 1.8 5.321e-07 1.8 5.36e-07 1.8 5.361e-07 0 5.4e-07 0 5.401e-07 0 5.44e-07 0 5.441e-07 0 5.48e-07 0 5.48e-07 1.8 5.52e-07 1.8 5.521e-07 1.8 5.56e-07 1.8 5.561e-07 1.8 5.6e-07 1.8 5.601e-07 1.8 5.64e-07 1.8 5.641e-07 0 5.68e-07 0 5.681e-07 0 5.72e-07 0 5.72e-07 0 5.76e-07 0 5.761e-07 0 5.8e-07 0 5.801e-07 1.8 5.84e-07 1.8 5.841e-07 0 5.88e-07 0 5.881e-07 0 5.92e-07 0 5.921e-07 1.8 5.96e-07 1.8 5.96e-07 0 6e-07 0 6.001e-07 0 6.04e-07 0 6.041e-07 1.8 6.08e-07 1.8 6.081e-07 1.8 6.12e-07 1.8 6.121e-07 0 6.16e-07 0 6.161e-07 1.8 6.2e-07 1.8 6.2e-07 0 6.24e-07 0 6.241e-07 1.8 6.28e-07 1.8 6.281e-07 1.8 6.32e-07 1.8 6.321e-07 0 6.36e-07 0 6.361e-07 1.8 6.4e-07 1.8 6.401e-07 0 6.44e-07 0 6.441e-07 1.8 6.48e-07 1.8 6.481e-07 0 6.52e-07 0 6.521e-07 0 6.56e-07 0 6.561e-07 0 6.6e-07 0 6.601e-07 0 6.64e-07 0 6.641e-07 1.8 6.68e-07 1.8 6.681e-07 0 6.72e-07 0 6.721e-07 0 6.76e-07 0 6.761e-07 1.8 6.8e-07 1.8 6.801e-07 0 6.84e-07 0 6.841e-07 1.8 6.88e-07 1.8 6.881e-07 1.8 6.92e-07 1.8 6.921e-07 1.8 6.96e-07 1.8 6.961e-07 1.8 7e-07 1.8 7.001e-07 1.8 7.04e-07 1.8 7.041e-07 0 7.08e-07 0 7.081e-07 0 7.12e-07 0 7.121e-07 0 7.16e-07 0 7.161e-07 1.8 7.2e-07 1.8 7.201e-07 0 7.24e-07 0 7.241e-07 0 7.28e-07 0 7.281e-07 1.8 7.32e-07 1.8 7.321e-07 0 7.36e-07 0 7.361e-07 0 7.4e-07 0 7.401e-07 1.8 7.44e-07 1.8 7.441e-07 1.8 7.48e-07 1.8 7.481e-07 0 7.52e-07 0 7.521e-07 0 7.56e-07 0 7.561e-07 0 7.6e-07 0 7.601e-07 1.8 7.64e-07 1.8 7.641e-07 1.8 7.68e-07 1.8 7.681e-07 0 7.72e-07 0 7.721e-07 0 7.76e-07 0 7.761e-07 1.8 7.8e-07 1.8 7.801e-07 1.8 7.84e-07 1.8 7.841e-07 0 7.88e-07 0 7.881e-07 0 7.92e-07 0 7.921e-07 1.8 7.96e-07 1.8 7.961e-07 1.8 8e-07 1.8 8.001e-07 1.8 8.04e-07 1.8 8.041e-07 1.8 8.08e-07 1.8 8.081e-07 0 8.12e-07 0 8.121e-07 1.8 8.16e-07 1.8 8.161e-07 0 8.2e-07 0 8.201e-07 1.8 8.24e-07 1.8 8.241e-07 1.8 8.28e-07 1.8 8.281e-07 1.8 8.32e-07 1.8 8.321e-07 0 8.36e-07 0 8.361e-07 0 8.4e-07 0 8.401e-07 1.8 8.44e-07 1.8 8.441e-07 0 8.48e-07 0 8.481e-07 1.8 8.52e-07 1.8 8.521e-07 0 8.56e-07 0 8.561e-07 1.8 8.6e-07 1.8 8.601e-07 0 8.64e-07 0 8.641e-07 1.8 8.68e-07 1.8 8.681e-07 0 8.72e-07 0 8.721e-07 1.8 8.76e-07 1.8 8.761e-07 1.8 8.8e-07 1.8 8.801e-07 1.8 8.84e-07 1.8 8.841e-07 1.8 8.88e-07 1.8 8.881e-07 0 8.92e-07 0 8.921e-07 1.8 8.96e-07 1.8 8.961e-07 1.8 9e-07 1.8 9.001e-07 1.8 9.04e-07 1.8 9.041e-07 1.8 9.08e-07 1.8 9.081e-07 0 9.12e-07 0 9.121e-07 0 9.16e-07 0 9.161e-07 0 9.2e-07 0 9.201e-07 1.8 9.24e-07 1.8 9.241e-07 1.8 9.28e-07 1.8 9.281e-07 0 9.32e-07 0 9.321e-07 0 9.36e-07 0 9.361e-07 1.8 9.4e-07 1.8 9.401e-07 1.8 9.44e-07 1.8 9.441e-07 1.8 9.48e-07 1.8 9.481e-07 0 9.52e-07 0 9.521e-07 1.8 9.56e-07 1.8 9.56e-07 1.8 9.6e-07 1.8 9.601e-07 1.8 9.64e-07 1.8 9.64e-07 0 9.68e-07 0 9.68e-07 1.8 9.72e-07 1.8 9.72e-07 1.8 9.76e-07 1.8 9.76e-07 1.8 9.8e-07 1.8 9.801e-07 0 9.84e-07 0 9.84e-07 0 9.88e-07 0 9.881e-07 1.8 9.92e-07 1.8 9.92e-07 0 9.96e-07 0 9.96e-07 1.8 1e-06 1.8 1e-06 1.8 1.004e-06 1.8 1.004e-06 1.8 1.008e-06 1.8 1.008e-06 0 1.012e-06 0 1.012e-06 0 1.016e-06 0 1.016e-06 1.8 1.02e-06 1.8 1.02e-06 1.8 1.024e-06 1.8 1.024e-06 1.8 1.028e-06 1.8 1.028e-06 1.8 1.032e-06 1.8 1.032e-06 1.8 1.036e-06 1.8 1.036e-06 1.8)
VB0 B0 0 PWL(0 1.8 4e-09 1.8 4.05e-09 0 8e-09 0 8.05e-09 1.8 1.2e-08 1.8 1.205e-08 1.8 1.6e-08 1.8 1.605e-08 0 2e-08 0 2.005e-08 0 2.4e-08 0 2.405e-08 0 2.8e-08 0 2.805e-08 1.8 3.2e-08 1.8 3.205e-08 0 3.6e-08 0 3.605e-08 0 4e-08 0 4.005e-08 1.8 4.4e-08 1.8 4.405e-08 0 4.8e-08 0 4.805e-08 1.8 5.2e-08 1.8 5.205e-08 0 5.6e-08 0 5.605e-08 1.8 6e-08 1.8 6.005e-08 0 6.4e-08 0 6.405e-08 0 6.8e-08 0 6.805e-08 1.8 7.2e-08 1.8 7.205e-08 1.8 7.6e-08 1.8 7.605e-08 0 8e-08 0 8.005e-08 0 8.4e-08 0 8.405e-08 0 8.8e-08 0 8.805e-08 0 9.2e-08 0 9.205e-08 0 9.6e-08 0 9.605e-08 1.8 1e-07 1.8 1.001e-07 1.8 1.04e-07 1.8 1.041e-07 0 1.08e-07 0 1.081e-07 1.8 1.12e-07 1.8 1.121e-07 1.8 1.16e-07 1.8 1.161e-07 1.8 1.2e-07 1.8 1.201e-07 1.8 1.24e-07 1.8 1.241e-07 0 1.28e-07 0 1.281e-07 1.8 1.32e-07 1.8 1.321e-07 0 1.36e-07 0 1.361e-07 1.8 1.4e-07 1.8 1.401e-07 1.8 1.44e-07 1.8 1.441e-07 1.8 1.48e-07 1.8 1.481e-07 0 1.52e-07 0 1.521e-07 0 1.56e-07 0 1.561e-07 1.8 1.6e-07 1.8 1.601e-07 0 1.64e-07 0 1.641e-07 1.8 1.68e-07 1.8 1.681e-07 0 1.72e-07 0 1.721e-07 0 1.76e-07 0 1.761e-07 0 1.8e-07 0 1.801e-07 1.8 1.84e-07 1.8 1.841e-07 0 1.88e-07 0 1.881e-07 0 1.92e-07 0 1.921e-07 0 1.96e-07 0 1.961e-07 0 2e-07 0 2.001e-07 0 2.04e-07 0 2.041e-07 1.8 2.08e-07 1.8 2.081e-07 0 2.12e-07 0 2.121e-07 1.8 2.16e-07 1.8 2.161e-07 1.8 2.2e-07 1.8 2.201e-07 1.8 2.24e-07 1.8 2.241e-07 1.8 2.28e-07 1.8 2.281e-07 0 2.32e-07 0 2.321e-07 0 2.36e-07 0 2.361e-07 1.8 2.4e-07 1.8 2.401e-07 0 2.44e-07 0 2.441e-07 1.8 2.48e-07 1.8 2.481e-07 0 2.52e-07 0 2.521e-07 1.8 2.56e-07 1.8 2.561e-07 0 2.6e-07 0 2.601e-07 1.8 2.64e-07 1.8 2.641e-07 0 2.68e-07 0 2.681e-07 1.8 2.72e-07 1.8 2.721e-07 0 2.76e-07 0 2.761e-07 0 2.8e-07 0 2.801e-07 0 2.84e-07 0 2.841e-07 1.8 2.88e-07 1.8 2.881e-07 1.8 2.92e-07 1.8 2.921e-07 1.8 2.96e-07 1.8 2.961e-07 1.8 3e-07 1.8 3.001e-07 1.8 3.04e-07 1.8 3.041e-07 0 3.08e-07 0 3.081e-07 0 3.12e-07 0 3.121e-07 0 3.16e-07 0 3.161e-07 0 3.2e-07 0 3.201e-07 1.8 3.24e-07 1.8 3.241e-07 0 3.28e-07 0 3.281e-07 0 3.32e-07 0 3.321e-07 1.8 3.36e-07 1.8 3.361e-07 0 3.4e-07 0 3.401e-07 0 3.44e-07 0 3.441e-07 0 3.48e-07 0 3.481e-07 0 3.52e-07 0 3.521e-07 1.8 3.56e-07 1.8 3.561e-07 1.8 3.6e-07 1.8 3.601e-07 1.8 3.64e-07 1.8 3.641e-07 1.8 3.68e-07 1.8 3.681e-07 0 3.72e-07 0 3.721e-07 1.8 3.76e-07 1.8 3.761e-07 1.8 3.8e-07 1.8 3.801e-07 0 3.84e-07 0 3.841e-07 1.8 3.88e-07 1.8 3.881e-07 0 3.92e-07 0 3.921e-07 1.8 3.96e-07 1.8 3.961e-07 1.8 4e-07 1.8 4.001e-07 1.8 4.04e-07 1.8 4.041e-07 0 4.08e-07 0 4.081e-07 0 4.12e-07 0 4.121e-07 0 4.16e-07 0 4.161e-07 0 4.2e-07 0 4.201e-07 1.8 4.24e-07 1.8 4.241e-07 0 4.28e-07 0 4.281e-07 0 4.32e-07 0 4.321e-07 1.8 4.36e-07 1.8 4.361e-07 1.8 4.4e-07 1.8 4.401e-07 0 4.44e-07 0 4.441e-07 1.8 4.48e-07 1.8 4.481e-07 0 4.52e-07 0 4.521e-07 1.8 4.56e-07 1.8 4.561e-07 0 4.6e-07 0 4.601e-07 0 4.64e-07 0 4.641e-07 1.8 4.68e-07 1.8 4.681e-07 0 4.72e-07 0 4.721e-07 0 4.76e-07 0 4.761e-07 0 4.8e-07 0 4.801e-07 1.8 4.84e-07 1.8 4.841e-07 0 4.88e-07 0 4.881e-07 0 4.92e-07 0 4.921e-07 1.8 4.96e-07 1.8 4.96e-07 1.8 5e-07 1.8 5.001e-07 0 5.04e-07 0 5.041e-07 1.8 5.08e-07 1.8 5.081e-07 1.8 5.12e-07 1.8 5.121e-07 0 5.16e-07 0 5.161e-07 1.8 5.2e-07 1.8 5.201e-07 1.8 5.24e-07 1.8 5.24e-07 0 5.28e-07 0 5.281e-07 0 5.32e-07 0 5.321e-07 0 5.36e-07 0 5.361e-07 0 5.4e-07 0 5.401e-07 1.8 5.44e-07 1.8 5.441e-07 1.8 5.48e-07 1.8 5.48e-07 1.8 5.52e-07 1.8 5.521e-07 0 5.56e-07 0 5.561e-07 1.8 5.6e-07 1.8 5.601e-07 0 5.64e-07 0 5.641e-07 0 5.68e-07 0 5.681e-07 1.8 5.72e-07 1.8 5.72e-07 1.8 5.76e-07 1.8 5.761e-07 1.8 5.8e-07 1.8 5.801e-07 0 5.84e-07 0 5.841e-07 1.8 5.88e-07 1.8 5.881e-07 1.8 5.92e-07 1.8 5.921e-07 1.8 5.96e-07 1.8 5.96e-07 1.8 6e-07 1.8 6.001e-07 0 6.04e-07 0 6.041e-07 0 6.08e-07 0 6.081e-07 0 6.12e-07 0 6.121e-07 1.8 6.16e-07 1.8 6.161e-07 1.8 6.2e-07 1.8 6.2e-07 0 6.24e-07 0 6.241e-07 0 6.28e-07 0 6.281e-07 0 6.32e-07 0 6.321e-07 0 6.36e-07 0 6.361e-07 1.8 6.4e-07 1.8 6.401e-07 1.8 6.44e-07 1.8 6.441e-07 1.8 6.48e-07 1.8 6.481e-07 0 6.52e-07 0 6.521e-07 1.8 6.56e-07 1.8 6.561e-07 0 6.6e-07 0 6.601e-07 0 6.64e-07 0 6.641e-07 1.8 6.68e-07 1.8 6.681e-07 0 6.72e-07 0 6.721e-07 0 6.76e-07 0 6.761e-07 1.8 6.8e-07 1.8 6.801e-07 0 6.84e-07 0 6.841e-07 0 6.88e-07 0 6.881e-07 0 6.92e-07 0 6.921e-07 0 6.96e-07 0 6.961e-07 1.8 7e-07 1.8 7.001e-07 0 7.04e-07 0 7.041e-07 0 7.08e-07 0 7.081e-07 0 7.12e-07 0 7.121e-07 0 7.16e-07 0 7.161e-07 0 7.2e-07 0 7.201e-07 1.8 7.24e-07 1.8 7.241e-07 1.8 7.28e-07 1.8 7.281e-07 1.8 7.32e-07 1.8 7.321e-07 1.8 7.36e-07 1.8 7.361e-07 0 7.4e-07 0 7.401e-07 1.8 7.44e-07 1.8 7.441e-07 0 7.48e-07 0 7.481e-07 0 7.52e-07 0 7.521e-07 1.8 7.56e-07 1.8 7.561e-07 1.8 7.6e-07 1.8 7.601e-07 1.8 7.64e-07 1.8 7.641e-07 0 7.68e-07 0 7.681e-07 0 7.72e-07 0 7.721e-07 0 7.76e-07 0 7.761e-07 1.8 7.8e-07 1.8 7.801e-07 1.8 7.84e-07 1.8 7.841e-07 0 7.88e-07 0 7.881e-07 0 7.92e-07 0 7.921e-07 1.8 7.96e-07 1.8 7.961e-07 1.8 8e-07 1.8 8.001e-07 0 8.04e-07 0 8.041e-07 1.8 8.08e-07 1.8 8.081e-07 0 8.12e-07 0 8.121e-07 0 8.16e-07 0 8.161e-07 1.8 8.2e-07 1.8 8.201e-07 0 8.24e-07 0 8.241e-07 0 8.28e-07 0 8.281e-07 0 8.32e-07 0 8.321e-07 0 8.36e-07 0 8.361e-07 0 8.4e-07 0 8.401e-07 0 8.44e-07 0 8.441e-07 1.8 8.48e-07 1.8 8.481e-07 1.8 8.52e-07 1.8 8.521e-07 1.8 8.56e-07 1.8 8.561e-07 1.8 8.6e-07 1.8 8.601e-07 0 8.64e-07 0 8.641e-07 1.8 8.68e-07 1.8 8.681e-07 1.8 8.72e-07 1.8 8.721e-07 0 8.76e-07 0 8.761e-07 1.8 8.8e-07 1.8 8.801e-07 1.8 8.84e-07 1.8 8.841e-07 1.8 8.88e-07 1.8 8.881e-07 0 8.92e-07 0 8.921e-07 1.8 8.96e-07 1.8 8.961e-07 1.8 9e-07 1.8 9.001e-07 1.8 9.04e-07 1.8 9.041e-07 0 9.08e-07 0 9.081e-07 1.8 9.12e-07 1.8 9.121e-07 1.8 9.16e-07 1.8 9.161e-07 0 9.2e-07 0 9.201e-07 1.8 9.24e-07 1.8 9.241e-07 0 9.28e-07 0 9.281e-07 0 9.32e-07 0 9.321e-07 0 9.36e-07 0 9.361e-07 0 9.4e-07 0 9.401e-07 0 9.44e-07 0 9.441e-07 0 9.48e-07 0 9.481e-07 1.8 9.52e-07 1.8 9.521e-07 0 9.56e-07 0 9.56e-07 1.8 9.6e-07 1.8 9.601e-07 0 9.64e-07 0 9.64e-07 1.8 9.68e-07 1.8 9.68e-07 0 9.72e-07 0 9.72e-07 1.8 9.76e-07 1.8 9.76e-07 1.8 9.8e-07 1.8 9.801e-07 0 9.84e-07 0 9.84e-07 0 9.88e-07 0 9.881e-07 1.8 9.92e-07 1.8 9.92e-07 0 9.96e-07 0 9.96e-07 0 1e-06 0 1e-06 0 1.004e-06 0 1.004e-06 1.8 1.008e-06 1.8 1.008e-06 1.8 1.012e-06 1.8 1.012e-06 0 1.016e-06 0 1.016e-06 0 1.02e-06 0 1.02e-06 0 1.024e-06 0 1.024e-06 0 1.028e-06 0 1.028e-06 0 1.032e-06 0 1.032e-06 0 1.036e-06 0 1.036e-06 0)
VB1 B1 0 PWL(0 0 4e-09 0 4.05e-09 1.8 8e-09 1.8 8.05e-09 0 1.2e-08 0 1.205e-08 1.8 1.6e-08 1.8 1.605e-08 1.8 2e-08 1.8 2.005e-08 1.8 2.4e-08 1.8 2.405e-08 0 2.8e-08 0 2.805e-08 0 3.2e-08 0 3.205e-08 0 3.6e-08 0 3.605e-08 0 4e-08 0 4.005e-08 1.8 4.4e-08 1.8 4.405e-08 0 4.8e-08 0 4.805e-08 0 5.2e-08 0 5.205e-08 0 5.6e-08 0 5.605e-08 0 6e-08 0 6.005e-08 1.8 6.4e-08 1.8 6.405e-08 1.8 6.8e-08 1.8 6.805e-08 0 7.2e-08 0 7.205e-08 1.8 7.6e-08 1.8 7.605e-08 0 8e-08 0 8.005e-08 0 8.4e-08 0 8.405e-08 0 8.8e-08 0 8.805e-08 0 9.2e-08 0 9.205e-08 0 9.6e-08 0 9.605e-08 0 1e-07 0 1.001e-07 0 1.04e-07 0 1.041e-07 0 1.08e-07 0 1.081e-07 1.8 1.12e-07 1.8 1.121e-07 0 1.16e-07 0 1.161e-07 1.8 1.2e-07 1.8 1.201e-07 1.8 1.24e-07 1.8 1.241e-07 1.8 1.28e-07 1.8 1.281e-07 0 1.32e-07 0 1.321e-07 0 1.36e-07 0 1.361e-07 0 1.4e-07 0 1.401e-07 1.8 1.44e-07 1.8 1.441e-07 0 1.48e-07 0 1.481e-07 0 1.52e-07 0 1.521e-07 0 1.56e-07 0 1.561e-07 0 1.6e-07 0 1.601e-07 1.8 1.64e-07 1.8 1.641e-07 1.8 1.68e-07 1.8 1.681e-07 1.8 1.72e-07 1.8 1.721e-07 1.8 1.76e-07 1.8 1.761e-07 0 1.8e-07 0 1.801e-07 0 1.84e-07 0 1.841e-07 0 1.88e-07 0 1.881e-07 1.8 1.92e-07 1.8 1.921e-07 0 1.96e-07 0 1.961e-07 1.8 2e-07 1.8 2.001e-07 0 2.04e-07 0 2.041e-07 1.8 2.08e-07 1.8 2.081e-07 0 2.12e-07 0 2.121e-07 0 2.16e-07 0 2.161e-07 0 2.2e-07 0 2.201e-07 1.8 2.24e-07 1.8 2.241e-07 1.8 2.28e-07 1.8 2.281e-07 1.8 2.32e-07 1.8 2.321e-07 0 2.36e-07 0 2.361e-07 0 2.4e-07 0 2.401e-07 1.8 2.44e-07 1.8 2.441e-07 1.8 2.48e-07 1.8 2.481e-07 0 2.52e-07 0 2.521e-07 1.8 2.56e-07 1.8 2.561e-07 0 2.6e-07 0 2.601e-07 1.8 2.64e-07 1.8 2.641e-07 1.8 2.68e-07 1.8 2.681e-07 1.8 2.72e-07 1.8 2.721e-07 0 2.76e-07 0 2.761e-07 0 2.8e-07 0 2.801e-07 1.8 2.84e-07 1.8 2.841e-07 1.8 2.88e-07 1.8 2.881e-07 0 2.92e-07 0 2.921e-07 0 2.96e-07 0 2.961e-07 0 3e-07 0 3.001e-07 1.8 3.04e-07 1.8 3.041e-07 0 3.08e-07 0 3.081e-07 1.8 3.12e-07 1.8 3.121e-07 1.8 3.16e-07 1.8 3.161e-07 1.8 3.2e-07 1.8 3.201e-07 0 3.24e-07 0 3.241e-07 1.8 3.28e-07 1.8 3.281e-07 0 3.32e-07 0 3.321e-07 0 3.36e-07 0 3.361e-07 1.8 3.4e-07 1.8 3.401e-07 0 3.44e-07 0 3.441e-07 1.8 3.48e-07 1.8 3.481e-07 0 3.52e-07 0 3.521e-07 1.8 3.56e-07 1.8 3.561e-07 0 3.6e-07 0 3.601e-07 1.8 3.64e-07 1.8 3.641e-07 1.8 3.68e-07 1.8 3.681e-07 1.8 3.72e-07 1.8 3.721e-07 1.8 3.76e-07 1.8 3.761e-07 1.8 3.8e-07 1.8 3.801e-07 0 3.84e-07 0 3.841e-07 1.8 3.88e-07 1.8 3.881e-07 0 3.92e-07 0 3.921e-07 0 3.96e-07 0 3.961e-07 0 4e-07 0 4.001e-07 1.8 4.04e-07 1.8 4.041e-07 0 4.08e-07 0 4.081e-07 1.8 4.12e-07 1.8 4.121e-07 0 4.16e-07 0 4.161e-07 1.8 4.2e-07 1.8 4.201e-07 1.8 4.24e-07 1.8 4.241e-07 0 4.28e-07 0 4.281e-07 0 4.32e-07 0 4.321e-07 1.8 4.36e-07 1.8 4.361e-07 0 4.4e-07 0 4.401e-07 0 4.44e-07 0 4.441e-07 0 4.48e-07 0 4.481e-07 1.8 4.52e-07 1.8 4.521e-07 0 4.56e-07 0 4.561e-07 1.8 4.6e-07 1.8 4.601e-07 1.8 4.64e-07 1.8 4.641e-07 0 4.68e-07 0 4.681e-07 1.8 4.72e-07 1.8 4.721e-07 1.8 4.76e-07 1.8 4.761e-07 1.8 4.8e-07 1.8 4.801e-07 1.8 4.84e-07 1.8 4.841e-07 0 4.88e-07 0 4.881e-07 0 4.92e-07 0 4.921e-07 1.8 4.96e-07 1.8 4.96e-07 0 5e-07 0 5.001e-07 0 5.04e-07 0 5.041e-07 0 5.08e-07 0 5.081e-07 0 5.12e-07 0 5.121e-07 1.8 5.16e-07 1.8 5.161e-07 1.8 5.2e-07 1.8 5.201e-07 1.8 5.24e-07 1.8 5.24e-07 1.8 5.28e-07 1.8 5.281e-07 1.8 5.32e-07 1.8 5.321e-07 1.8 5.36e-07 1.8 5.361e-07 0 5.4e-07 0 5.401e-07 1.8 5.44e-07 1.8 5.441e-07 1.8 5.48e-07 1.8 5.48e-07 1.8 5.52e-07 1.8 5.521e-07 1.8 5.56e-07 1.8 5.561e-07 1.8 5.6e-07 1.8 5.601e-07 1.8 5.64e-07 1.8 5.641e-07 0 5.68e-07 0 5.681e-07 1.8 5.72e-07 1.8 5.72e-07 0 5.76e-07 0 5.761e-07 1.8 5.8e-07 1.8 5.801e-07 1.8 5.84e-07 1.8 5.841e-07 0 5.88e-07 0 5.881e-07 0 5.92e-07 0 5.921e-07 1.8 5.96e-07 1.8 5.96e-07 0 6e-07 0 6.001e-07 1.8 6.04e-07 1.8 6.041e-07 0 6.08e-07 0 6.081e-07 0 6.12e-07 0 6.121e-07 1.8 6.16e-07 1.8 6.161e-07 0 6.2e-07 0 6.2e-07 1.8 6.24e-07 1.8 6.241e-07 0 6.28e-07 0 6.281e-07 0 6.32e-07 0 6.321e-07 0 6.36e-07 0 6.361e-07 0 6.4e-07 0 6.401e-07 0 6.44e-07 0 6.441e-07 1.8 6.48e-07 1.8 6.481e-07 0 6.52e-07 0 6.521e-07 1.8 6.56e-07 1.8 6.561e-07 1.8 6.6e-07 1.8 6.601e-07 0 6.64e-07 0 6.641e-07 0 6.68e-07 0 6.681e-07 1.8 6.72e-07 1.8 6.721e-07 1.8 6.76e-07 1.8 6.761e-07 0 6.8e-07 0 6.801e-07 0 6.84e-07 0 6.841e-07 0 6.88e-07 0 6.881e-07 1.8 6.92e-07 1.8 6.921e-07 1.8 6.96e-07 1.8 6.961e-07 1.8 7e-07 1.8 7.001e-07 0 7.04e-07 0 7.041e-07 0 7.08e-07 0 7.081e-07 1.8 7.12e-07 1.8 7.121e-07 1.8 7.16e-07 1.8 7.161e-07 1.8 7.2e-07 1.8 7.201e-07 0 7.24e-07 0 7.241e-07 0 7.28e-07 0 7.281e-07 0 7.32e-07 0 7.321e-07 0 7.36e-07 0 7.361e-07 1.8 7.4e-07 1.8 7.401e-07 1.8 7.44e-07 1.8 7.441e-07 0 7.48e-07 0 7.481e-07 0 7.52e-07 0 7.521e-07 1.8 7.56e-07 1.8 7.561e-07 0 7.6e-07 0 7.601e-07 0 7.64e-07 0 7.641e-07 1.8 7.68e-07 1.8 7.681e-07 1.8 7.72e-07 1.8 7.721e-07 0 7.76e-07 0 7.761e-07 1.8 7.8e-07 1.8 7.801e-07 1.8 7.84e-07 1.8 7.841e-07 0 7.88e-07 0 7.881e-07 1.8 7.92e-07 1.8 7.921e-07 0 7.96e-07 0 7.961e-07 0 8e-07 0 8.001e-07 0 8.04e-07 0 8.041e-07 0 8.08e-07 0 8.081e-07 0 8.12e-07 0 8.121e-07 1.8 8.16e-07 1.8 8.161e-07 1.8 8.2e-07 1.8 8.201e-07 0 8.24e-07 0 8.241e-07 1.8 8.28e-07 1.8 8.281e-07 1.8 8.32e-07 1.8 8.321e-07 1.8 8.36e-07 1.8 8.361e-07 1.8 8.4e-07 1.8 8.401e-07 1.8 8.44e-07 1.8 8.441e-07 0 8.48e-07 0 8.481e-07 1.8 8.52e-07 1.8 8.521e-07 0 8.56e-07 0 8.561e-07 0 8.6e-07 0 8.601e-07 1.8 8.64e-07 1.8 8.641e-07 1.8 8.68e-07 1.8 8.681e-07 0 8.72e-07 0 8.721e-07 0 8.76e-07 0 8.761e-07 0 8.8e-07 0 8.801e-07 0 8.84e-07 0 8.841e-07 0 8.88e-07 0 8.881e-07 1.8 8.92e-07 1.8 8.921e-07 0 8.96e-07 0 8.961e-07 1.8 9e-07 1.8 9.001e-07 0 9.04e-07 0 9.041e-07 1.8 9.08e-07 1.8 9.081e-07 1.8 9.12e-07 1.8 9.121e-07 0 9.16e-07 0 9.161e-07 1.8 9.2e-07 1.8 9.201e-07 1.8 9.24e-07 1.8 9.241e-07 0 9.28e-07 0 9.281e-07 1.8 9.32e-07 1.8 9.321e-07 0 9.36e-07 0 9.361e-07 1.8 9.4e-07 1.8 9.401e-07 0 9.44e-07 0 9.441e-07 0 9.48e-07 0 9.481e-07 0 9.52e-07 0 9.521e-07 1.8 9.56e-07 1.8 9.56e-07 1.8 9.6e-07 1.8 9.601e-07 1.8 9.64e-07 1.8 9.64e-07 0 9.68e-07 0 9.68e-07 0 9.72e-07 0 9.72e-07 0 9.76e-07 0 9.76e-07 0 9.8e-07 0 9.801e-07 0 9.84e-07 0 9.84e-07 0 9.88e-07 0 9.881e-07 1.8 9.92e-07 1.8 9.92e-07 0 9.96e-07 0 9.96e-07 0 1e-06 0 1e-06 0 1.004e-06 0 1.004e-06 1.8 1.008e-06 1.8 1.008e-06 0 1.012e-06 0 1.012e-06 0 1.016e-06 0 1.016e-06 1.8 1.02e-06 1.8 1.02e-06 0 1.024e-06 0 1.024e-06 0 1.028e-06 0 1.028e-06 0 1.032e-06 0 1.032e-06 0 1.036e-06 0 1.036e-06 0)
VB2 B2 0 PWL(0 0 4e-09 0 4.05e-09 0 8e-09 0 8.05e-09 0 1.2e-08 0 1.205e-08 1.8 1.6e-08 1.8 1.605e-08 1.8 2e-08 1.8 2.005e-08 0 2.4e-08 0 2.405e-08 0 2.8e-08 0 2.805e-08 0 3.2e-08 0 3.205e-08 0 3.6e-08 0 3.605e-08 0 4e-08 0 4.005e-08 0 4.4e-08 0 4.405e-08 0 4.8e-08 0 4.805e-08 0 5.2e-08 0 5.205e-08 1.8 5.6e-08 1.8 5.605e-08 1.8 6e-08 1.8 6.005e-08 1.8 6.4e-08 1.8 6.405e-08 1.8 6.8e-08 1.8 6.805e-08 0 7.2e-08 0 7.205e-08 0 7.6e-08 0 7.605e-08 1.8 8e-08 1.8 8.005e-08 0 8.4e-08 0 8.405e-08 1.8 8.8e-08 1.8 8.805e-08 0 9.2e-08 0 9.205e-08 0 9.6e-08 0 9.605e-08 1.8 1e-07 1.8 1.001e-07 1.8 1.04e-07 1.8 1.041e-07 1.8 1.08e-07 1.8 1.081e-07 1.8 1.12e-07 1.8 1.121e-07 1.8 1.16e-07 1.8 1.161e-07 0 1.2e-07 0 1.201e-07 1.8 1.24e-07 1.8 1.241e-07 0 1.28e-07 0 1.281e-07 0 1.32e-07 0 1.321e-07 1.8 1.36e-07 1.8 1.361e-07 0 1.4e-07 0 1.401e-07 0 1.44e-07 0 1.441e-07 1.8 1.48e-07 1.8 1.481e-07 0 1.52e-07 0 1.521e-07 0 1.56e-07 0 1.561e-07 1.8 1.6e-07 1.8 1.601e-07 1.8 1.64e-07 1.8 1.641e-07 1.8 1.68e-07 1.8 1.681e-07 0 1.72e-07 0 1.721e-07 0 1.76e-07 0 1.761e-07 1.8 1.8e-07 1.8 1.801e-07 1.8 1.84e-07 1.8 1.841e-07 1.8 1.88e-07 1.8 1.881e-07 1.8 1.92e-07 1.8 1.921e-07 1.8 1.96e-07 1.8 1.961e-07 0 2e-07 0 2.001e-07 0 2.04e-07 0 2.041e-07 1.8 2.08e-07 1.8 2.081e-07 0 2.12e-07 0 2.121e-07 0 2.16e-07 0 2.161e-07 0 2.2e-07 0 2.201e-07 0 2.24e-07 0 2.241e-07 0 2.28e-07 0 2.281e-07 0 2.32e-07 0 2.321e-07 1.8 2.36e-07 1.8 2.361e-07 1.8 2.4e-07 1.8 2.401e-07 0 2.44e-07 0 2.441e-07 1.8 2.48e-07 1.8 2.481e-07 1.8 2.52e-07 1.8 2.521e-07 0 2.56e-07 0 2.561e-07 1.8 2.6e-07 1.8 2.601e-07 1.8 2.64e-07 1.8 2.641e-07 1.8 2.68e-07 1.8 2.681e-07 1.8 2.72e-07 1.8 2.721e-07 1.8 2.76e-07 1.8 2.761e-07 0 2.8e-07 0 2.801e-07 1.8 2.84e-07 1.8 2.841e-07 0 2.88e-07 0 2.881e-07 0 2.92e-07 0 2.921e-07 1.8 2.96e-07 1.8 2.961e-07 0 3e-07 0 3.001e-07 1.8 3.04e-07 1.8 3.041e-07 1.8 3.08e-07 1.8 3.081e-07 1.8 3.12e-07 1.8 3.121e-07 1.8 3.16e-07 1.8 3.161e-07 0 3.2e-07 0 3.201e-07 0 3.24e-07 0 3.241e-07 1.8 3.28e-07 1.8 3.281e-07 0 3.32e-07 0 3.321e-07 1.8 3.36e-07 1.8 3.361e-07 0 3.4e-07 0 3.401e-07 1.8 3.44e-07 1.8 3.441e-07 1.8 3.48e-07 1.8 3.481e-07 1.8 3.52e-07 1.8 3.521e-07 1.8 3.56e-07 1.8 3.561e-07 1.8 3.6e-07 1.8 3.601e-07 0 3.64e-07 0 3.641e-07 0 3.68e-07 0 3.681e-07 1.8 3.72e-07 1.8 3.721e-07 1.8 3.76e-07 1.8 3.761e-07 1.8 3.8e-07 1.8 3.801e-07 0 3.84e-07 0 3.841e-07 0 3.88e-07 0 3.881e-07 1.8 3.92e-07 1.8 3.921e-07 0 3.96e-07 0 3.961e-07 1.8 4e-07 1.8 4.001e-07 0 4.04e-07 0 4.041e-07 0 4.08e-07 0 4.081e-07 1.8 4.12e-07 1.8 4.121e-07 1.8 4.16e-07 1.8 4.161e-07 0 4.2e-07 0 4.201e-07 1.8 4.24e-07 1.8 4.241e-07 1.8 4.28e-07 1.8 4.281e-07 0 4.32e-07 0 4.321e-07 0 4.36e-07 0 4.361e-07 1.8 4.4e-07 1.8 4.401e-07 1.8 4.44e-07 1.8 4.441e-07 0 4.48e-07 0 4.481e-07 0 4.52e-07 0 4.521e-07 0 4.56e-07 0 4.561e-07 1.8 4.6e-07 1.8 4.601e-07 1.8 4.64e-07 1.8 4.641e-07 0 4.68e-07 0 4.681e-07 1.8 4.72e-07 1.8 4.721e-07 1.8 4.76e-07 1.8 4.761e-07 0 4.8e-07 0 4.801e-07 0 4.84e-07 0 4.841e-07 1.8 4.88e-07 1.8 4.881e-07 1.8 4.92e-07 1.8 4.921e-07 1.8 4.96e-07 1.8 4.96e-07 1.8 5e-07 1.8 5.001e-07 0 5.04e-07 0 5.041e-07 0 5.08e-07 0 5.081e-07 0 5.12e-07 0 5.121e-07 0 5.16e-07 0 5.161e-07 1.8 5.2e-07 1.8 5.201e-07 0 5.24e-07 0 5.24e-07 1.8 5.28e-07 1.8 5.281e-07 1.8 5.32e-07 1.8 5.321e-07 1.8 5.36e-07 1.8 5.361e-07 1.8 5.4e-07 1.8 5.401e-07 1.8 5.44e-07 1.8 5.441e-07 0 5.48e-07 0 5.48e-07 1.8 5.52e-07 1.8 5.521e-07 1.8 5.56e-07 1.8 5.561e-07 0 5.6e-07 0 5.601e-07 0 5.64e-07 0 5.641e-07 0 5.68e-07 0 5.681e-07 1.8 5.72e-07 1.8 5.72e-07 1.8 5.76e-07 1.8 5.761e-07 0 5.8e-07 0 5.801e-07 1.8 5.84e-07 1.8 5.841e-07 1.8 5.88e-07 1.8 5.881e-07 1.8 5.92e-07 1.8 5.921e-07 1.8 5.96e-07 1.8 5.96e-07 1.8 6e-07 1.8 6.001e-07 1.8 6.04e-07 1.8 6.041e-07 0 6.08e-07 0 6.081e-07 0 6.12e-07 0 6.121e-07 1.8 6.16e-07 1.8 6.161e-07 0 6.2e-07 0 6.2e-07 1.8 6.24e-07 1.8 6.241e-07 0 6.28e-07 0 6.281e-07 0 6.32e-07 0 6.321e-07 0 6.36e-07 0 6.361e-07 1.8 6.4e-07 1.8 6.401e-07 1.8 6.44e-07 1.8 6.441e-07 0 6.48e-07 0 6.481e-07 1.8 6.52e-07 1.8 6.521e-07 0 6.56e-07 0 6.561e-07 1.8 6.6e-07 1.8 6.601e-07 0 6.64e-07 0 6.641e-07 1.8 6.68e-07 1.8 6.681e-07 1.8 6.72e-07 1.8 6.721e-07 0 6.76e-07 0 6.761e-07 0 6.8e-07 0 6.801e-07 0 6.84e-07 0 6.841e-07 0 6.88e-07 0 6.881e-07 0 6.92e-07 0 6.921e-07 1.8 6.96e-07 1.8 6.961e-07 0 7e-07 0 7.001e-07 1.8 7.04e-07 1.8 7.041e-07 1.8 7.08e-07 1.8 7.081e-07 1.8 7.12e-07 1.8 7.121e-07 1.8 7.16e-07 1.8 7.161e-07 1.8 7.2e-07 1.8 7.201e-07 1.8 7.24e-07 1.8 7.241e-07 1.8 7.28e-07 1.8 7.281e-07 1.8 7.32e-07 1.8 7.321e-07 1.8 7.36e-07 1.8 7.361e-07 1.8 7.4e-07 1.8 7.401e-07 1.8 7.44e-07 1.8 7.441e-07 1.8 7.48e-07 1.8 7.481e-07 0 7.52e-07 0 7.521e-07 1.8 7.56e-07 1.8 7.561e-07 1.8 7.6e-07 1.8 7.601e-07 1.8 7.64e-07 1.8 7.641e-07 1.8 7.68e-07 1.8 7.681e-07 1.8 7.72e-07 1.8 7.721e-07 1.8 7.76e-07 1.8 7.761e-07 1.8 7.8e-07 1.8 7.801e-07 0 7.84e-07 0 7.841e-07 1.8 7.88e-07 1.8 7.881e-07 1.8 7.92e-07 1.8 7.921e-07 1.8 7.96e-07 1.8 7.961e-07 1.8 8e-07 1.8 8.001e-07 0 8.04e-07 0 8.041e-07 1.8 8.08e-07 1.8 8.081e-07 0 8.12e-07 0 8.121e-07 0 8.16e-07 0 8.161e-07 1.8 8.2e-07 1.8 8.201e-07 0 8.24e-07 0 8.241e-07 0 8.28e-07 0 8.281e-07 0 8.32e-07 0 8.321e-07 0 8.36e-07 0 8.361e-07 0 8.4e-07 0 8.401e-07 0 8.44e-07 0 8.441e-07 1.8 8.48e-07 1.8 8.481e-07 1.8 8.52e-07 1.8 8.521e-07 1.8 8.56e-07 1.8 8.561e-07 0 8.6e-07 0 8.601e-07 0 8.64e-07 0 8.641e-07 1.8 8.68e-07 1.8 8.681e-07 1.8 8.72e-07 1.8 8.721e-07 1.8 8.76e-07 1.8 8.761e-07 1.8 8.8e-07 1.8 8.801e-07 0 8.84e-07 0 8.841e-07 1.8 8.88e-07 1.8 8.881e-07 0 8.92e-07 0 8.921e-07 1.8 8.96e-07 1.8 8.961e-07 0 9e-07 0 9.001e-07 1.8 9.04e-07 1.8 9.041e-07 1.8 9.08e-07 1.8 9.081e-07 0 9.12e-07 0 9.121e-07 0 9.16e-07 0 9.161e-07 0 9.2e-07 0 9.201e-07 0 9.24e-07 0 9.241e-07 1.8 9.28e-07 1.8 9.281e-07 1.8 9.32e-07 1.8 9.321e-07 0 9.36e-07 0 9.361e-07 0 9.4e-07 0 9.401e-07 0 9.44e-07 0 9.441e-07 1.8 9.48e-07 1.8 9.481e-07 1.8 9.52e-07 1.8 9.521e-07 1.8 9.56e-07 1.8 9.56e-07 0 9.6e-07 0 9.601e-07 1.8 9.64e-07 1.8 9.64e-07 0 9.68e-07 0 9.68e-07 1.8 9.72e-07 1.8 9.72e-07 0 9.76e-07 0 9.76e-07 0 9.8e-07 0 9.801e-07 0 9.84e-07 0 9.84e-07 0 9.88e-07 0 9.881e-07 0 9.92e-07 0 9.92e-07 0 9.96e-07 0 9.96e-07 1.8 1e-06 1.8 1e-06 1.8 1.004e-06 1.8 1.004e-06 0 1.008e-06 0 1.008e-06 1.8 1.012e-06 1.8 1.012e-06 1.8 1.016e-06 1.8 1.016e-06 0 1.02e-06 0 1.02e-06 1.8 1.024e-06 1.8 1.024e-06 0 1.028e-06 0 1.028e-06 0 1.032e-06 0 1.032e-06 0 1.036e-06 0 1.036e-06 0)
VB3 B3 0 PWL(0 0 4e-09 0 4.05e-09 1.8 8e-09 1.8 8.05e-09 1.8 1.2e-08 1.8 1.205e-08 0 1.6e-08 0 1.605e-08 1.8 2e-08 1.8 2.005e-08 0 2.4e-08 0 2.405e-08 0 2.8e-08 0 2.805e-08 1.8 3.2e-08 1.8 3.205e-08 1.8 3.6e-08 1.8 3.605e-08 1.8 4e-08 1.8 4.005e-08 1.8 4.4e-08 1.8 4.405e-08 1.8 4.8e-08 1.8 4.805e-08 0 5.2e-08 0 5.205e-08 1.8 5.6e-08 1.8 5.605e-08 1.8 6e-08 1.8 6.005e-08 0 6.4e-08 0 6.405e-08 1.8 6.8e-08 1.8 6.805e-08 0 7.2e-08 0 7.205e-08 0 7.6e-08 0 7.605e-08 1.8 8e-08 1.8 8.005e-08 1.8 8.4e-08 1.8 8.405e-08 1.8 8.8e-08 1.8 8.805e-08 1.8 9.2e-08 1.8 9.205e-08 1.8 9.6e-08 1.8 9.605e-08 0 1e-07 0 1.001e-07 1.8 1.04e-07 1.8 1.041e-07 1.8 1.08e-07 1.8 1.081e-07 1.8 1.12e-07 1.8 1.121e-07 0 1.16e-07 0 1.161e-07 1.8 1.2e-07 1.8 1.201e-07 0 1.24e-07 0 1.241e-07 0 1.28e-07 0 1.281e-07 1.8 1.32e-07 1.8 1.321e-07 0 1.36e-07 0 1.361e-07 0 1.4e-07 0 1.401e-07 1.8 1.44e-07 1.8 1.441e-07 0 1.48e-07 0 1.481e-07 0 1.52e-07 0 1.521e-07 1.8 1.56e-07 1.8 1.561e-07 0 1.6e-07 0 1.601e-07 1.8 1.64e-07 1.8 1.641e-07 1.8 1.68e-07 1.8 1.681e-07 0 1.72e-07 0 1.721e-07 1.8 1.76e-07 1.8 1.761e-07 1.8 1.8e-07 1.8 1.801e-07 0 1.84e-07 0 1.841e-07 0 1.88e-07 0 1.881e-07 1.8 1.92e-07 1.8 1.921e-07 1.8 1.96e-07 1.8 1.961e-07 0 2e-07 0 2.001e-07 0 2.04e-07 0 2.041e-07 0 2.08e-07 0 2.081e-07 1.8 2.12e-07 1.8 2.121e-07 0 2.16e-07 0 2.161e-07 1.8 2.2e-07 1.8 2.201e-07 1.8 2.24e-07 1.8 2.241e-07 0 2.28e-07 0 2.281e-07 0 2.32e-07 0 2.321e-07 0 2.36e-07 0 2.361e-07 1.8 2.4e-07 1.8 2.401e-07 1.8 2.44e-07 1.8 2.441e-07 1.8 2.48e-07 1.8 2.481e-07 1.8 2.52e-07 1.8 2.521e-07 1.8 2.56e-07 1.8 2.561e-07 0 2.6e-07 0 2.601e-07 0 2.64e-07 0 2.641e-07 0 2.68e-07 0 2.681e-07 1.8 2.72e-07 1.8 2.721e-07 1.8 2.76e-07 1.8 2.761e-07 1.8 2.8e-07 1.8 2.801e-07 1.8 2.84e-07 1.8 2.841e-07 0 2.88e-07 0 2.881e-07 0 2.92e-07 0 2.921e-07 1.8 2.96e-07 1.8 2.961e-07 1.8 3e-07 1.8 3.001e-07 1.8 3.04e-07 1.8 3.041e-07 1.8 3.08e-07 1.8 3.081e-07 0 3.12e-07 0 3.121e-07 1.8 3.16e-07 1.8 3.161e-07 0 3.2e-07 0 3.201e-07 1.8 3.24e-07 1.8 3.241e-07 1.8 3.28e-07 1.8 3.281e-07 1.8 3.32e-07 1.8 3.321e-07 1.8 3.36e-07 1.8 3.361e-07 1.8 3.4e-07 1.8 3.401e-07 1.8 3.44e-07 1.8 3.441e-07 1.8 3.48e-07 1.8 3.481e-07 1.8 3.52e-07 1.8 3.521e-07 0 3.56e-07 0 3.561e-07 1.8 3.6e-07 1.8 3.601e-07 1.8 3.64e-07 1.8 3.641e-07 1.8 3.68e-07 1.8 3.681e-07 1.8 3.72e-07 1.8 3.721e-07 0 3.76e-07 0 3.761e-07 1.8 3.8e-07 1.8 3.801e-07 1.8 3.84e-07 1.8 3.841e-07 0 3.88e-07 0 3.881e-07 0 3.92e-07 0 3.921e-07 1.8 3.96e-07 1.8 3.961e-07 0 4e-07 0 4.001e-07 0 4.04e-07 0 4.041e-07 1.8 4.08e-07 1.8 4.081e-07 0 4.12e-07 0 4.121e-07 1.8 4.16e-07 1.8 4.161e-07 0 4.2e-07 0 4.201e-07 1.8 4.24e-07 1.8 4.241e-07 0 4.28e-07 0 4.281e-07 1.8 4.32e-07 1.8 4.321e-07 0 4.36e-07 0 4.361e-07 1.8 4.4e-07 1.8 4.401e-07 1.8 4.44e-07 1.8 4.441e-07 1.8 4.48e-07 1.8 4.481e-07 1.8 4.52e-07 1.8 4.521e-07 0 4.56e-07 0 4.561e-07 0 4.6e-07 0 4.601e-07 0 4.64e-07 0 4.641e-07 0 4.68e-07 0 4.681e-07 1.8 4.72e-07 1.8 4.721e-07 0 4.76e-07 0 4.761e-07 1.8 4.8e-07 1.8 4.801e-07 0 4.84e-07 0 4.841e-07 1.8 4.88e-07 1.8 4.881e-07 0 4.92e-07 0 4.921e-07 0 4.96e-07 0 4.96e-07 1.8 5e-07 1.8 5.001e-07 0 5.04e-07 0 5.041e-07 0 5.08e-07 0 5.081e-07 0 5.12e-07 0 5.121e-07 1.8 5.16e-07 1.8 5.161e-07 1.8 5.2e-07 1.8 5.201e-07 1.8 5.24e-07 1.8 5.24e-07 1.8 5.28e-07 1.8 5.281e-07 0 5.32e-07 0 5.321e-07 0 5.36e-07 0 5.361e-07 1.8 5.4e-07 1.8 5.401e-07 1.8 5.44e-07 1.8 5.441e-07 0 5.48e-07 0 5.48e-07 0 5.52e-07 0 5.521e-07 0 5.56e-07 0 5.561e-07 1.8 5.6e-07 1.8 5.601e-07 1.8 5.64e-07 1.8 5.641e-07 0 5.68e-07 0 5.681e-07 0 5.72e-07 0 5.72e-07 0 5.76e-07 0 5.761e-07 0 5.8e-07 0 5.801e-07 0 5.84e-07 0 5.841e-07 1.8 5.88e-07 1.8 5.881e-07 1.8 5.92e-07 1.8 5.921e-07 1.8 5.96e-07 1.8 5.96e-07 1.8 6e-07 1.8 6.001e-07 0 6.04e-07 0 6.041e-07 1.8 6.08e-07 1.8 6.081e-07 0 6.12e-07 0 6.121e-07 0 6.16e-07 0 6.161e-07 1.8 6.2e-07 1.8 6.2e-07 0 6.24e-07 0 6.241e-07 0 6.28e-07 0 6.281e-07 1.8 6.32e-07 1.8 6.321e-07 1.8 6.36e-07 1.8 6.361e-07 1.8 6.4e-07 1.8 6.401e-07 1.8 6.44e-07 1.8 6.441e-07 1.8 6.48e-07 1.8 6.481e-07 1.8 6.52e-07 1.8 6.521e-07 0 6.56e-07 0 6.561e-07 0 6.6e-07 0 6.601e-07 0 6.64e-07 0 6.641e-07 1.8 6.68e-07 1.8 6.681e-07 0 6.72e-07 0 6.721e-07 0 6.76e-07 0 6.761e-07 0 6.8e-07 0 6.801e-07 1.8 6.84e-07 1.8 6.841e-07 0 6.88e-07 0 6.881e-07 0 6.92e-07 0 6.921e-07 1.8 6.96e-07 1.8 6.961e-07 0 7e-07 0 7.001e-07 0 7.04e-07 0 7.041e-07 1.8 7.08e-07 1.8 7.081e-07 0 7.12e-07 0 7.121e-07 0 7.16e-07 0 7.161e-07 0 7.2e-07 0 7.201e-07 1.8 7.24e-07 1.8 7.241e-07 1.8 7.28e-07 1.8 7.281e-07 1.8 7.32e-07 1.8 7.321e-07 0 7.36e-07 0 7.361e-07 1.8 7.4e-07 1.8 7.401e-07 1.8 7.44e-07 1.8 7.441e-07 1.8 7.48e-07 1.8 7.481e-07 0 7.52e-07 0 7.521e-07 1.8 7.56e-07 1.8 7.561e-07 1.8 7.6e-07 1.8 7.601e-07 1.8 7.64e-07 1.8 7.641e-07 1.8 7.68e-07 1.8 7.681e-07 0 7.72e-07 0 7.721e-07 1.8 7.76e-07 1.8 7.761e-07 0 7.8e-07 0 7.801e-07 1.8 7.84e-07 1.8 7.841e-07 0 7.88e-07 0 7.881e-07 0 7.92e-07 0 7.921e-07 1.8 7.96e-07 1.8 7.961e-07 1.8 8e-07 1.8 8.001e-07 0 8.04e-07 0 8.041e-07 0 8.08e-07 0 8.081e-07 0 8.12e-07 0 8.121e-07 1.8 8.16e-07 1.8 8.161e-07 1.8 8.2e-07 1.8 8.201e-07 1.8 8.24e-07 1.8 8.241e-07 0 8.28e-07 0 8.281e-07 1.8 8.32e-07 1.8 8.321e-07 1.8 8.36e-07 1.8 8.361e-07 0 8.4e-07 0 8.401e-07 0 8.44e-07 0 8.441e-07 1.8 8.48e-07 1.8 8.481e-07 1.8 8.52e-07 1.8 8.521e-07 0 8.56e-07 0 8.561e-07 1.8 8.6e-07 1.8 8.601e-07 1.8 8.64e-07 1.8 8.641e-07 1.8 8.68e-07 1.8 8.681e-07 1.8 8.72e-07 1.8 8.721e-07 1.8 8.76e-07 1.8 8.761e-07 0 8.8e-07 0 8.801e-07 0 8.84e-07 0 8.841e-07 1.8 8.88e-07 1.8 8.881e-07 1.8 8.92e-07 1.8 8.921e-07 0 8.96e-07 0 8.961e-07 1.8 9e-07 1.8 9.001e-07 1.8 9.04e-07 1.8 9.041e-07 0 9.08e-07 0 9.081e-07 1.8 9.12e-07 1.8 9.121e-07 0 9.16e-07 0 9.161e-07 1.8 9.2e-07 1.8 9.201e-07 0 9.24e-07 0 9.241e-07 1.8 9.28e-07 1.8 9.281e-07 1.8 9.32e-07 1.8 9.321e-07 1.8 9.36e-07 1.8 9.361e-07 1.8 9.4e-07 1.8 9.401e-07 1.8 9.44e-07 1.8 9.441e-07 1.8 9.48e-07 1.8 9.481e-07 1.8 9.52e-07 1.8 9.521e-07 1.8 9.56e-07 1.8 9.56e-07 1.8 9.6e-07 1.8 9.601e-07 1.8 9.64e-07 1.8 9.64e-07 1.8 9.68e-07 1.8 9.68e-07 1.8 9.72e-07 1.8 9.72e-07 0 9.76e-07 0 9.76e-07 0 9.8e-07 0 9.801e-07 1.8 9.84e-07 1.8 9.84e-07 0 9.88e-07 0 9.881e-07 1.8 9.92e-07 1.8 9.92e-07 0 9.96e-07 0 9.96e-07 1.8 1e-06 1.8 1e-06 0 1.004e-06 0 1.004e-06 1.8 1.008e-06 1.8 1.008e-06 0 1.012e-06 0 1.012e-06 1.8 1.016e-06 1.8 1.016e-06 1.8 1.02e-06 1.8 1.02e-06 0 1.024e-06 0 1.024e-06 0 1.028e-06 0 1.028e-06 0 1.032e-06 0 1.032e-06 0 1.036e-06 0 1.036e-06 0)
VS0 S0 0 PWL(0 0 4e-09 0 4.05e-09 0 8e-09 0 8.05e-09 0 1.2e-08 0 1.205e-08 0 1.6e-08 0 1.605e-08 0 2e-08 0 2.005e-08 0 2.4e-08 0 2.405e-08 0 2.8e-08 0 2.805e-08 0 3.2e-08 0 3.205e-08 0 3.6e-08 0 3.605e-08 0 4e-08 0 4.005e-08 0 4.4e-08 0 4.405e-08 0 4.8e-08 0 4.805e-08 0 5.2e-08 0 5.205e-08 0 5.6e-08 0 5.605e-08 0 6e-08 0 6.005e-08 0 6.4e-08 0 6.405e-08 1.8 6.8e-08 1.8 6.805e-08 1.8 7.2e-08 1.8 7.205e-08 1.8 7.6e-08 1.8 7.605e-08 1.8 8e-08 1.8 8.005e-08 1.8 8.4e-08 1.8 8.405e-08 1.8 8.8e-08 1.8 8.805e-08 1.8 9.2e-08 1.8 9.205e-08 1.8 9.6e-08 1.8 9.605e-08 1.8 1e-07 1.8 1.001e-07 1.8 1.04e-07 1.8 1.041e-07 1.8 1.08e-07 1.8 1.081e-07 1.8 1.12e-07 1.8 1.121e-07 1.8 1.16e-07 1.8 1.161e-07 1.8 1.2e-07 1.8 1.201e-07 1.8 1.24e-07 1.8 1.241e-07 1.8 1.28e-07 1.8 1.281e-07 0 1.32e-07 0 1.321e-07 0 1.36e-07 0 1.361e-07 0 1.4e-07 0 1.401e-07 0 1.44e-07 0 1.441e-07 0 1.48e-07 0 1.481e-07 0 1.52e-07 0 1.521e-07 0 1.56e-07 0 1.561e-07 0 1.6e-07 0 1.601e-07 0 1.64e-07 0 1.641e-07 0 1.68e-07 0 1.681e-07 0 1.72e-07 0 1.721e-07 0 1.76e-07 0 1.761e-07 0 1.8e-07 0 1.801e-07 0 1.84e-07 0 1.841e-07 0 1.88e-07 0 1.881e-07 0 1.92e-07 0 1.921e-07 1.8 1.96e-07 1.8 1.961e-07 1.8 2e-07 1.8 2.001e-07 1.8 2.04e-07 1.8 2.041e-07 1.8 2.08e-07 1.8 2.081e-07 1.8 2.12e-07 1.8 2.121e-07 1.8 2.16e-07 1.8 2.161e-07 1.8 2.2e-07 1.8 2.201e-07 1.8 2.24e-07 1.8 2.241e-07 1.8 2.28e-07 1.8 2.281e-07 1.8 2.32e-07 1.8 2.321e-07 1.8 2.36e-07 1.8 2.361e-07 1.8 2.4e-07 1.8 2.401e-07 1.8 2.44e-07 1.8 2.441e-07 1.8 2.48e-07 1.8 2.481e-07 1.8 2.52e-07 1.8 2.521e-07 1.8 2.56e-07 1.8 2.561e-07 0 2.6e-07 0 2.601e-07 0 2.64e-07 0 2.641e-07 0 2.68e-07 0 2.681e-07 0 2.72e-07 0 2.721e-07 0 2.76e-07 0 2.761e-07 0 2.8e-07 0 2.801e-07 0 2.84e-07 0 2.841e-07 0 2.88e-07 0 2.881e-07 0 2.92e-07 0 2.921e-07 0 2.96e-07 0 2.961e-07 0 3e-07 0 3.001e-07 0 3.04e-07 0 3.041e-07 0 3.08e-07 0 3.081e-07 0 3.12e-07 0 3.121e-07 0 3.16e-07 0 3.161e-07 0 3.2e-07 0 3.201e-07 1.8 3.24e-07 1.8 3.241e-07 1.8 3.28e-07 1.8 3.281e-07 1.8 3.32e-07 1.8 3.321e-07 1.8 3.36e-07 1.8 3.361e-07 1.8 3.4e-07 1.8 3.401e-07 1.8 3.44e-07 1.8 3.441e-07 1.8 3.48e-07 1.8 3.481e-07 1.8 3.52e-07 1.8 3.521e-07 1.8 3.56e-07 1.8 3.561e-07 1.8 3.6e-07 1.8 3.601e-07 1.8 3.64e-07 1.8 3.641e-07 1.8 3.68e-07 1.8 3.681e-07 1.8 3.72e-07 1.8 3.721e-07 1.8 3.76e-07 1.8 3.761e-07 1.8 3.8e-07 1.8 3.801e-07 1.8 3.84e-07 1.8 3.841e-07 0 3.88e-07 0 3.881e-07 0 3.92e-07 0 3.921e-07 0 3.96e-07 0 3.961e-07 0 4e-07 0 4.001e-07 0 4.04e-07 0 4.041e-07 0 4.08e-07 0 4.081e-07 0 4.12e-07 0 4.121e-07 0 4.16e-07 0 4.161e-07 0 4.2e-07 0 4.201e-07 0 4.24e-07 0 4.241e-07 0 4.28e-07 0 4.281e-07 0 4.32e-07 0 4.321e-07 0 4.36e-07 0 4.361e-07 0 4.4e-07 0 4.401e-07 0 4.44e-07 0 4.441e-07 0 4.48e-07 0 4.481e-07 1.8 4.52e-07 1.8 4.521e-07 1.8 4.56e-07 1.8 4.561e-07 1.8 4.6e-07 1.8 4.601e-07 1.8 4.64e-07 1.8 4.641e-07 1.8 4.68e-07 1.8 4.681e-07 1.8 4.72e-07 1.8 4.721e-07 1.8 4.76e-07 1.8 4.761e-07 1.8 4.8e-07 1.8 4.801e-07 1.8 4.84e-07 1.8 4.841e-07 1.8 4.88e-07 1.8 4.881e-07 1.8 4.92e-07 1.8 4.921e-07 1.8 4.96e-07 1.8 4.96e-07 1.8 5e-07 1.8 5.001e-07 1.8 5.04e-07 1.8 5.041e-07 1.8 5.08e-07 1.8 5.081e-07 1.8 5.12e-07 1.8 5.121e-07 0 5.16e-07 0 5.161e-07 0 5.2e-07 0 5.201e-07 0 5.24e-07 0 5.24e-07 0 5.28e-07 0 5.281e-07 0 5.32e-07 0 5.321e-07 0 5.36e-07 0 5.361e-07 0 5.4e-07 0 5.401e-07 0 5.44e-07 0 5.441e-07 0 5.48e-07 0 5.48e-07 0 5.52e-07 0 5.521e-07 0 5.56e-07 0 5.561e-07 0 5.6e-07 0 5.601e-07 0 5.64e-07 0 5.641e-07 0 5.68e-07 0 5.681e-07 0 5.72e-07 0 5.72e-07 0 5.76e-07 0 5.761e-07 1.8 5.8e-07 1.8 5.801e-07 1.8 5.84e-07 1.8 5.841e-07 1.8 5.88e-07 1.8 5.881e-07 1.8 5.92e-07 1.8 5.921e-07 1.8 5.96e-07 1.8 5.96e-07 1.8 6e-07 1.8 6.001e-07 1.8 6.04e-07 1.8 6.041e-07 1.8 6.08e-07 1.8 6.081e-07 1.8 6.12e-07 1.8 6.121e-07 1.8 6.16e-07 1.8 6.161e-07 1.8 6.2e-07 1.8 6.2e-07 1.8 6.24e-07 1.8 6.241e-07 1.8 6.28e-07 1.8 6.281e-07 1.8 6.32e-07 1.8 6.321e-07 1.8 6.36e-07 1.8 6.361e-07 1.8 6.4e-07 1.8 6.401e-07 0 6.44e-07 0 6.441e-07 0 6.48e-07 0 6.481e-07 0 6.52e-07 0 6.521e-07 0 6.56e-07 0 6.561e-07 0 6.6e-07 0 6.601e-07 0 6.64e-07 0 6.641e-07 0 6.68e-07 0 6.681e-07 0 6.72e-07 0 6.721e-07 0 6.76e-07 0 6.761e-07 0 6.8e-07 0 6.801e-07 0 6.84e-07 0 6.841e-07 0 6.88e-07 0 6.881e-07 0 6.92e-07 0 6.921e-07 0 6.96e-07 0 6.961e-07 0 7e-07 0 7.001e-07 0 7.04e-07 0 7.041e-07 1.8 7.08e-07 1.8 7.081e-07 1.8 7.12e-07 1.8 7.121e-07 1.8 7.16e-07 1.8 7.161e-07 1.8 7.2e-07 1.8 7.201e-07 1.8 7.24e-07 1.8 7.241e-07 1.8 7.28e-07 1.8 7.281e-07 1.8 7.32e-07 1.8 7.321e-07 1.8 7.36e-07 1.8 7.361e-07 1.8 7.4e-07 1.8 7.401e-07 1.8 7.44e-07 1.8 7.441e-07 1.8 7.48e-07 1.8 7.481e-07 1.8 7.52e-07 1.8 7.521e-07 1.8 7.56e-07 1.8 7.561e-07 1.8 7.6e-07 1.8 7.601e-07 1.8 7.64e-07 1.8 7.641e-07 1.8 7.68e-07 1.8 7.681e-07 0 7.72e-07 0 7.721e-07 0 7.76e-07 0 7.761e-07 0 7.8e-07 0 7.801e-07 0 7.84e-07 0 7.841e-07 0 7.88e-07 0 7.881e-07 0 7.92e-07 0 7.921e-07 0 7.96e-07 0 7.961e-07 0 8e-07 0 8.001e-07 0 8.04e-07 0 8.041e-07 0 8.08e-07 0 8.081e-07 0 8.12e-07 0 8.121e-07 0 8.16e-07 0 8.161e-07 0 8.2e-07 0 8.201e-07 0 8.24e-07 0 8.241e-07 0 8.28e-07 0 8.281e-07 0 8.32e-07 0 8.321e-07 1.8 8.36e-07 1.8 8.361e-07 1.8 8.4e-07 1.8 8.401e-07 1.8 8.44e-07 1.8 8.441e-07 1.8 8.48e-07 1.8 8.481e-07 1.8 8.52e-07 1.8 8.521e-07 1.8 8.56e-07 1.8 8.561e-07 1.8 8.6e-07 1.8 8.601e-07 1.8 8.64e-07 1.8 8.641e-07 1.8 8.68e-07 1.8 8.681e-07 1.8 8.72e-07 1.8 8.721e-07 1.8 8.76e-07 1.8 8.761e-07 1.8 8.8e-07 1.8 8.801e-07 1.8 8.84e-07 1.8 8.841e-07 1.8 8.88e-07 1.8 8.881e-07 1.8 8.92e-07 1.8 8.921e-07 1.8 8.96e-07 1.8 8.961e-07 0 9e-07 0 9.001e-07 0 9.04e-07 0 9.041e-07 0 9.08e-07 0 9.081e-07 0 9.12e-07 0 9.121e-07 0 9.16e-07 0 9.161e-07 0 9.2e-07 0 9.201e-07 0 9.24e-07 0 9.241e-07 0 9.28e-07 0 9.281e-07 0 9.32e-07 0 9.321e-07 0 9.36e-07 0 9.361e-07 0 9.4e-07 0 9.401e-07 0 9.44e-07 0 9.441e-07 0 9.48e-07 0 9.481e-07 0 9.52e-07 0 9.521e-07 0 9.56e-07 0 9.56e-07 0 9.6e-07 0 9.601e-07 1.8 9.64e-07 1.8 9.64e-07 1.8 9.68e-07 1.8 9.68e-07 1.8 9.72e-07 1.8 9.72e-07 1.8 9.76e-07 1.8 9.76e-07 1.8 9.8e-07 1.8 9.801e-07 1.8 9.84e-07 1.8 9.84e-07 1.8 9.88e-07 1.8 9.881e-07 1.8 9.92e-07 1.8 9.92e-07 1.8 9.96e-07 1.8 9.96e-07 1.8 1e-06 1.8 1e-06 1.8 1.004e-06 1.8 1.004e-06 1.8 1.008e-06 1.8 1.008e-06 1.8 1.012e-06 1.8 1.012e-06 1.8 1.016e-06 1.8 1.016e-06 1.8 1.02e-06 1.8 1.02e-06 1.8 1.024e-06 1.8 1.024e-06 1.8 1.028e-06 1.8 1.028e-06 1.8 1.032e-06 1.8 1.032e-06 1.8 1.036e-06 1.8 1.036e-06 1.8)
VS1 S1 0 PWL(0 0 4e-09 0 4.05e-09 0 8e-09 0 8.05e-09 0 1.2e-08 0 1.205e-08 0 1.6e-08 0 1.605e-08 0 2e-08 0 2.005e-08 0 2.4e-08 0 2.405e-08 0 2.8e-08 0 2.805e-08 0 3.2e-08 0 3.205e-08 0 3.6e-08 0 3.605e-08 0 4e-08 0 4.005e-08 0 4.4e-08 0 4.405e-08 0 4.8e-08 0 4.805e-08 0 5.2e-08 0 5.205e-08 0 5.6e-08 0 5.605e-08 0 6e-08 0 6.005e-08 0 6.4e-08 0 6.405e-08 0 6.8e-08 0 6.805e-08 0 7.2e-08 0 7.205e-08 0 7.6e-08 0 7.605e-08 0 8e-08 0 8.005e-08 0 8.4e-08 0 8.405e-08 0 8.8e-08 0 8.805e-08 0 9.2e-08 0 9.205e-08 0 9.6e-08 0 9.605e-08 0 1e-07 0 1.001e-07 0 1.04e-07 0 1.041e-07 0 1.08e-07 0 1.081e-07 0 1.12e-07 0 1.121e-07 0 1.16e-07 0 1.161e-07 0 1.2e-07 0 1.201e-07 0 1.24e-07 0 1.241e-07 0 1.28e-07 0 1.281e-07 1.8 1.32e-07 1.8 1.321e-07 1.8 1.36e-07 1.8 1.361e-07 1.8 1.4e-07 1.8 1.401e-07 1.8 1.44e-07 1.8 1.441e-07 1.8 1.48e-07 1.8 1.481e-07 1.8 1.52e-07 1.8 1.521e-07 1.8 1.56e-07 1.8 1.561e-07 1.8 1.6e-07 1.8 1.601e-07 1.8 1.64e-07 1.8 1.641e-07 1.8 1.68e-07 1.8 1.681e-07 1.8 1.72e-07 1.8 1.721e-07 1.8 1.76e-07 1.8 1.761e-07 1.8 1.8e-07 1.8 1.801e-07 1.8 1.84e-07 1.8 1.841e-07 1.8 1.88e-07 1.8 1.881e-07 1.8 1.92e-07 1.8 1.921e-07 1.8 1.96e-07 1.8 1.961e-07 1.8 2e-07 1.8 2.001e-07 1.8 2.04e-07 1.8 2.041e-07 1.8 2.08e-07 1.8 2.081e-07 1.8 2.12e-07 1.8 2.121e-07 1.8 2.16e-07 1.8 2.161e-07 1.8 2.2e-07 1.8 2.201e-07 1.8 2.24e-07 1.8 2.241e-07 1.8 2.28e-07 1.8 2.281e-07 1.8 2.32e-07 1.8 2.321e-07 1.8 2.36e-07 1.8 2.361e-07 1.8 2.4e-07 1.8 2.401e-07 1.8 2.44e-07 1.8 2.441e-07 1.8 2.48e-07 1.8 2.481e-07 1.8 2.52e-07 1.8 2.521e-07 1.8 2.56e-07 1.8 2.561e-07 0 2.6e-07 0 2.601e-07 0 2.64e-07 0 2.641e-07 0 2.68e-07 0 2.681e-07 0 2.72e-07 0 2.721e-07 0 2.76e-07 0 2.761e-07 0 2.8e-07 0 2.801e-07 0 2.84e-07 0 2.841e-07 0 2.88e-07 0 2.881e-07 0 2.92e-07 0 2.921e-07 0 2.96e-07 0 2.961e-07 0 3e-07 0 3.001e-07 0 3.04e-07 0 3.041e-07 0 3.08e-07 0 3.081e-07 0 3.12e-07 0 3.121e-07 0 3.16e-07 0 3.161e-07 0 3.2e-07 0 3.201e-07 0 3.24e-07 0 3.241e-07 0 3.28e-07 0 3.281e-07 0 3.32e-07 0 3.321e-07 0 3.36e-07 0 3.361e-07 0 3.4e-07 0 3.401e-07 0 3.44e-07 0 3.441e-07 0 3.48e-07 0 3.481e-07 0 3.52e-07 0 3.521e-07 0 3.56e-07 0 3.561e-07 0 3.6e-07 0 3.601e-07 0 3.64e-07 0 3.641e-07 0 3.68e-07 0 3.681e-07 0 3.72e-07 0 3.721e-07 0 3.76e-07 0 3.761e-07 0 3.8e-07 0 3.801e-07 0 3.84e-07 0 3.841e-07 1.8 3.88e-07 1.8 3.881e-07 1.8 3.92e-07 1.8 3.921e-07 1.8 3.96e-07 1.8 3.961e-07 1.8 4e-07 1.8 4.001e-07 1.8 4.04e-07 1.8 4.041e-07 1.8 4.08e-07 1.8 4.081e-07 1.8 4.12e-07 1.8 4.121e-07 1.8 4.16e-07 1.8 4.161e-07 1.8 4.2e-07 1.8 4.201e-07 1.8 4.24e-07 1.8 4.241e-07 1.8 4.28e-07 1.8 4.281e-07 1.8 4.32e-07 1.8 4.321e-07 1.8 4.36e-07 1.8 4.361e-07 1.8 4.4e-07 1.8 4.401e-07 1.8 4.44e-07 1.8 4.441e-07 1.8 4.48e-07 1.8 4.481e-07 1.8 4.52e-07 1.8 4.521e-07 1.8 4.56e-07 1.8 4.561e-07 1.8 4.6e-07 1.8 4.601e-07 1.8 4.64e-07 1.8 4.641e-07 1.8 4.68e-07 1.8 4.681e-07 1.8 4.72e-07 1.8 4.721e-07 1.8 4.76e-07 1.8 4.761e-07 1.8 4.8e-07 1.8 4.801e-07 1.8 4.84e-07 1.8 4.841e-07 1.8 4.88e-07 1.8 4.881e-07 1.8 4.92e-07 1.8 4.921e-07 1.8 4.96e-07 1.8 4.96e-07 1.8 5e-07 1.8 5.001e-07 1.8 5.04e-07 1.8 5.041e-07 1.8 5.08e-07 1.8 5.081e-07 1.8 5.12e-07 1.8 5.121e-07 0 5.16e-07 0 5.161e-07 0 5.2e-07 0 5.201e-07 0 5.24e-07 0 5.24e-07 0 5.28e-07 0 5.281e-07 0 5.32e-07 0 5.321e-07 0 5.36e-07 0 5.361e-07 0 5.4e-07 0 5.401e-07 0 5.44e-07 0 5.441e-07 0 5.48e-07 0 5.48e-07 0 5.52e-07 0 5.521e-07 0 5.56e-07 0 5.561e-07 0 5.6e-07 0 5.601e-07 0 5.64e-07 0 5.641e-07 0 5.68e-07 0 5.681e-07 0 5.72e-07 0 5.72e-07 0 5.76e-07 0 5.761e-07 0 5.8e-07 0 5.801e-07 0 5.84e-07 0 5.841e-07 0 5.88e-07 0 5.881e-07 0 5.92e-07 0 5.921e-07 0 5.96e-07 0 5.96e-07 0 6e-07 0 6.001e-07 0 6.04e-07 0 6.041e-07 0 6.08e-07 0 6.081e-07 0 6.12e-07 0 6.121e-07 0 6.16e-07 0 6.161e-07 0 6.2e-07 0 6.2e-07 0 6.24e-07 0 6.241e-07 0 6.28e-07 0 6.281e-07 0 6.32e-07 0 6.321e-07 0 6.36e-07 0 6.361e-07 0 6.4e-07 0 6.401e-07 1.8 6.44e-07 1.8 6.441e-07 1.8 6.48e-07 1.8 6.481e-07 1.8 6.52e-07 1.8 6.521e-07 1.8 6.56e-07 1.8 6.561e-07 1.8 6.6e-07 1.8 6.601e-07 1.8 6.64e-07 1.8 6.641e-07 1.8 6.68e-07 1.8 6.681e-07 1.8 6.72e-07 1.8 6.721e-07 1.8 6.76e-07 1.8 6.761e-07 1.8 6.8e-07 1.8 6.801e-07 1.8 6.84e-07 1.8 6.841e-07 1.8 6.88e-07 1.8 6.881e-07 1.8 6.92e-07 1.8 6.921e-07 1.8 6.96e-07 1.8 6.961e-07 1.8 7e-07 1.8 7.001e-07 1.8 7.04e-07 1.8 7.041e-07 1.8 7.08e-07 1.8 7.081e-07 1.8 7.12e-07 1.8 7.121e-07 1.8 7.16e-07 1.8 7.161e-07 1.8 7.2e-07 1.8 7.201e-07 1.8 7.24e-07 1.8 7.241e-07 1.8 7.28e-07 1.8 7.281e-07 1.8 7.32e-07 1.8 7.321e-07 1.8 7.36e-07 1.8 7.361e-07 1.8 7.4e-07 1.8 7.401e-07 1.8 7.44e-07 1.8 7.441e-07 1.8 7.48e-07 1.8 7.481e-07 1.8 7.52e-07 1.8 7.521e-07 1.8 7.56e-07 1.8 7.561e-07 1.8 7.6e-07 1.8 7.601e-07 1.8 7.64e-07 1.8 7.641e-07 1.8 7.68e-07 1.8 7.681e-07 0 7.72e-07 0 7.721e-07 0 7.76e-07 0 7.761e-07 0 7.8e-07 0 7.801e-07 0 7.84e-07 0 7.841e-07 0 7.88e-07 0 7.881e-07 0 7.92e-07 0 7.921e-07 0 7.96e-07 0 7.961e-07 0 8e-07 0 8.001e-07 0 8.04e-07 0 8.041e-07 0 8.08e-07 0 8.081e-07 0 8.12e-07 0 8.121e-07 0 8.16e-07 0 8.161e-07 0 8.2e-07 0 8.201e-07 0 8.24e-07 0 8.241e-07 0 8.28e-07 0 8.281e-07 0 8.32e-07 0 8.321e-07 0 8.36e-07 0 8.361e-07 0 8.4e-07 0 8.401e-07 0 8.44e-07 0 8.441e-07 0 8.48e-07 0 8.481e-07 0 8.52e-07 0 8.521e-07 0 8.56e-07 0 8.561e-07 0 8.6e-07 0 8.601e-07 0 8.64e-07 0 8.641e-07 0 8.68e-07 0 8.681e-07 0 8.72e-07 0 8.721e-07 0 8.76e-07 0 8.761e-07 0 8.8e-07 0 8.801e-07 0 8.84e-07 0 8.841e-07 0 8.88e-07 0 8.881e-07 0 8.92e-07 0 8.921e-07 0 8.96e-07 0 8.961e-07 1.8 9e-07 1.8 9.001e-07 1.8 9.04e-07 1.8 9.041e-07 1.8 9.08e-07 1.8 9.081e-07 1.8 9.12e-07 1.8 9.121e-07 1.8 9.16e-07 1.8 9.161e-07 1.8 9.2e-07 1.8 9.201e-07 1.8 9.24e-07 1.8 9.241e-07 1.8 9.28e-07 1.8 9.281e-07 1.8 9.32e-07 1.8 9.321e-07 1.8 9.36e-07 1.8 9.361e-07 1.8 9.4e-07 1.8 9.401e-07 1.8 9.44e-07 1.8 9.441e-07 1.8 9.48e-07 1.8 9.481e-07 1.8 9.52e-07 1.8 9.521e-07 1.8 9.56e-07 1.8 9.56e-07 1.8 9.6e-07 1.8 9.601e-07 1.8 9.64e-07 1.8 9.64e-07 1.8 9.68e-07 1.8 9.68e-07 1.8 9.72e-07 1.8 9.72e-07 1.8 9.76e-07 1.8 9.76e-07 1.8 9.8e-07 1.8 9.801e-07 1.8 9.84e-07 1.8 9.84e-07 1.8 9.88e-07 1.8 9.881e-07 1.8 9.92e-07 1.8 9.92e-07 1.8 9.96e-07 1.8 9.96e-07 1.8 1e-06 1.8 1e-06 1.8 1.004e-06 1.8 1.004e-06 1.8 1.008e-06 1.8 1.008e-06 1.8 1.012e-06 1.8 1.012e-06 1.8 1.016e-06 1.8 1.016e-06 1.8 1.02e-06 1.8 1.02e-06 1.8 1.024e-06 1.8 1.024e-06 0 1.028e-06 0 1.028e-06 0 1.032e-06 0 1.032e-06 0 1.036e-06 0 1.036e-06 0)
VS2 S2 0 PWL(0 0 4e-09 0 4.05e-09 0 8e-09 0 8.05e-09 0 1.2e-08 0 1.205e-08 0 1.6e-08 0 1.605e-08 0 2e-08 0 2.005e-08 0 2.4e-08 0 2.405e-08 0 2.8e-08 0 2.805e-08 0 3.2e-08 0 3.205e-08 0 3.6e-08 0 3.605e-08 0 4e-08 0 4.005e-08 0 4.4e-08 0 4.405e-08 0 4.8e-08 0 4.805e-08 0 5.2e-08 0 5.205e-08 0 5.6e-08 0 5.605e-08 0 6e-08 0 6.005e-08 0 6.4e-08 0 6.405e-08 0 6.8e-08 0 6.805e-08 0 7.2e-08 0 7.205e-08 0 7.6e-08 0 7.605e-08 0 8e-08 0 8.005e-08 0 8.4e-08 0 8.405e-08 0 8.8e-08 0 8.805e-08 0 9.2e-08 0 9.205e-08 0 9.6e-08 0 9.605e-08 0 1e-07 0 1.001e-07 0 1.04e-07 0 1.041e-07 0 1.08e-07 0 1.081e-07 0 1.12e-07 0 1.121e-07 0 1.16e-07 0 1.161e-07 0 1.2e-07 0 1.201e-07 0 1.24e-07 0 1.241e-07 0 1.28e-07 0 1.281e-07 0 1.32e-07 0 1.321e-07 0 1.36e-07 0 1.361e-07 0 1.4e-07 0 1.401e-07 0 1.44e-07 0 1.441e-07 0 1.48e-07 0 1.481e-07 0 1.52e-07 0 1.521e-07 0 1.56e-07 0 1.561e-07 0 1.6e-07 0 1.601e-07 0 1.64e-07 0 1.641e-07 0 1.68e-07 0 1.681e-07 0 1.72e-07 0 1.721e-07 0 1.76e-07 0 1.761e-07 0 1.8e-07 0 1.801e-07 0 1.84e-07 0 1.841e-07 0 1.88e-07 0 1.881e-07 0 1.92e-07 0 1.921e-07 0 1.96e-07 0 1.961e-07 0 2e-07 0 2.001e-07 0 2.04e-07 0 2.041e-07 0 2.08e-07 0 2.081e-07 0 2.12e-07 0 2.121e-07 0 2.16e-07 0 2.161e-07 0 2.2e-07 0 2.201e-07 0 2.24e-07 0 2.241e-07 0 2.28e-07 0 2.281e-07 0 2.32e-07 0 2.321e-07 0 2.36e-07 0 2.361e-07 0 2.4e-07 0 2.401e-07 0 2.44e-07 0 2.441e-07 0 2.48e-07 0 2.481e-07 0 2.52e-07 0 2.521e-07 0 2.56e-07 0 2.561e-07 1.8 2.6e-07 1.8 2.601e-07 1.8 2.64e-07 1.8 2.641e-07 1.8 2.68e-07 1.8 2.681e-07 1.8 2.72e-07 1.8 2.721e-07 1.8 2.76e-07 1.8 2.761e-07 1.8 2.8e-07 1.8 2.801e-07 1.8 2.84e-07 1.8 2.841e-07 1.8 2.88e-07 1.8 2.881e-07 1.8 2.92e-07 1.8 2.921e-07 1.8 2.96e-07 1.8 2.961e-07 1.8 3e-07 1.8 3.001e-07 1.8 3.04e-07 1.8 3.041e-07 1.8 3.08e-07 1.8 3.081e-07 1.8 3.12e-07 1.8 3.121e-07 1.8 3.16e-07 1.8 3.161e-07 1.8 3.2e-07 1.8 3.201e-07 1.8 3.24e-07 1.8 3.241e-07 1.8 3.28e-07 1.8 3.281e-07 1.8 3.32e-07 1.8 3.321e-07 1.8 3.36e-07 1.8 3.361e-07 1.8 3.4e-07 1.8 3.401e-07 1.8 3.44e-07 1.8 3.441e-07 1.8 3.48e-07 1.8 3.481e-07 1.8 3.52e-07 1.8 3.521e-07 1.8 3.56e-07 1.8 3.561e-07 1.8 3.6e-07 1.8 3.601e-07 1.8 3.64e-07 1.8 3.641e-07 1.8 3.68e-07 1.8 3.681e-07 1.8 3.72e-07 1.8 3.721e-07 1.8 3.76e-07 1.8 3.761e-07 1.8 3.8e-07 1.8 3.801e-07 1.8 3.84e-07 1.8 3.841e-07 1.8 3.88e-07 1.8 3.881e-07 1.8 3.92e-07 1.8 3.921e-07 1.8 3.96e-07 1.8 3.961e-07 1.8 4e-07 1.8 4.001e-07 1.8 4.04e-07 1.8 4.041e-07 1.8 4.08e-07 1.8 4.081e-07 1.8 4.12e-07 1.8 4.121e-07 1.8 4.16e-07 1.8 4.161e-07 1.8 4.2e-07 1.8 4.201e-07 1.8 4.24e-07 1.8 4.241e-07 1.8 4.28e-07 1.8 4.281e-07 1.8 4.32e-07 1.8 4.321e-07 1.8 4.36e-07 1.8 4.361e-07 1.8 4.4e-07 1.8 4.401e-07 1.8 4.44e-07 1.8 4.441e-07 1.8 4.48e-07 1.8 4.481e-07 1.8 4.52e-07 1.8 4.521e-07 1.8 4.56e-07 1.8 4.561e-07 1.8 4.6e-07 1.8 4.601e-07 1.8 4.64e-07 1.8 4.641e-07 1.8 4.68e-07 1.8 4.681e-07 1.8 4.72e-07 1.8 4.721e-07 1.8 4.76e-07 1.8 4.761e-07 1.8 4.8e-07 1.8 4.801e-07 1.8 4.84e-07 1.8 4.841e-07 1.8 4.88e-07 1.8 4.881e-07 1.8 4.92e-07 1.8 4.921e-07 1.8 4.96e-07 1.8 4.96e-07 1.8 5e-07 1.8 5.001e-07 1.8 5.04e-07 1.8 5.041e-07 1.8 5.08e-07 1.8 5.081e-07 1.8 5.12e-07 1.8 5.121e-07 0 5.16e-07 0 5.161e-07 0 5.2e-07 0 5.201e-07 0 5.24e-07 0 5.24e-07 0 5.28e-07 0 5.281e-07 0 5.32e-07 0 5.321e-07 0 5.36e-07 0 5.361e-07 0 5.4e-07 0 5.401e-07 0 5.44e-07 0 5.441e-07 0 5.48e-07 0 5.48e-07 0 5.52e-07 0 5.521e-07 0 5.56e-07 0 5.561e-07 0 5.6e-07 0 5.601e-07 0 5.64e-07 0 5.641e-07 0 5.68e-07 0 5.681e-07 0 5.72e-07 0 5.72e-07 0 5.76e-07 0 5.761e-07 0 5.8e-07 0 5.801e-07 0 5.84e-07 0 5.841e-07 0 5.88e-07 0 5.881e-07 0 5.92e-07 0 5.921e-07 0 5.96e-07 0 5.96e-07 0 6e-07 0 6.001e-07 0 6.04e-07 0 6.041e-07 0 6.08e-07 0 6.081e-07 0 6.12e-07 0 6.121e-07 0 6.16e-07 0 6.161e-07 0 6.2e-07 0 6.2e-07 0 6.24e-07 0 6.241e-07 0 6.28e-07 0 6.281e-07 0 6.32e-07 0 6.321e-07 0 6.36e-07 0 6.361e-07 0 6.4e-07 0 6.401e-07 0 6.44e-07 0 6.441e-07 0 6.48e-07 0 6.481e-07 0 6.52e-07 0 6.521e-07 0 6.56e-07 0 6.561e-07 0 6.6e-07 0 6.601e-07 0 6.64e-07 0 6.641e-07 0 6.68e-07 0 6.681e-07 0 6.72e-07 0 6.721e-07 0 6.76e-07 0 6.761e-07 0 6.8e-07 0 6.801e-07 0 6.84e-07 0 6.841e-07 0 6.88e-07 0 6.881e-07 0 6.92e-07 0 6.921e-07 0 6.96e-07 0 6.961e-07 0 7e-07 0 7.001e-07 0 7.04e-07 0 7.041e-07 0 7.08e-07 0 7.081e-07 0 7.12e-07 0 7.121e-07 0 7.16e-07 0 7.161e-07 0 7.2e-07 0 7.201e-07 0 7.24e-07 0 7.241e-07 0 7.28e-07 0 7.281e-07 0 7.32e-07 0 7.321e-07 0 7.36e-07 0 7.361e-07 0 7.4e-07 0 7.401e-07 0 7.44e-07 0 7.441e-07 0 7.48e-07 0 7.481e-07 0 7.52e-07 0 7.521e-07 0 7.56e-07 0 7.561e-07 0 7.6e-07 0 7.601e-07 0 7.64e-07 0 7.641e-07 0 7.68e-07 0 7.681e-07 1.8 7.72e-07 1.8 7.721e-07 1.8 7.76e-07 1.8 7.761e-07 1.8 7.8e-07 1.8 7.801e-07 1.8 7.84e-07 1.8 7.841e-07 1.8 7.88e-07 1.8 7.881e-07 1.8 7.92e-07 1.8 7.921e-07 1.8 7.96e-07 1.8 7.961e-07 1.8 8e-07 1.8 8.001e-07 1.8 8.04e-07 1.8 8.041e-07 1.8 8.08e-07 1.8 8.081e-07 1.8 8.12e-07 1.8 8.121e-07 1.8 8.16e-07 1.8 8.161e-07 1.8 8.2e-07 1.8 8.201e-07 1.8 8.24e-07 1.8 8.241e-07 1.8 8.28e-07 1.8 8.281e-07 1.8 8.32e-07 1.8 8.321e-07 1.8 8.36e-07 1.8 8.361e-07 1.8 8.4e-07 1.8 8.401e-07 1.8 8.44e-07 1.8 8.441e-07 1.8 8.48e-07 1.8 8.481e-07 1.8 8.52e-07 1.8 8.521e-07 1.8 8.56e-07 1.8 8.561e-07 1.8 8.6e-07 1.8 8.601e-07 1.8 8.64e-07 1.8 8.641e-07 1.8 8.68e-07 1.8 8.681e-07 1.8 8.72e-07 1.8 8.721e-07 1.8 8.76e-07 1.8 8.761e-07 1.8 8.8e-07 1.8 8.801e-07 1.8 8.84e-07 1.8 8.841e-07 1.8 8.88e-07 1.8 8.881e-07 1.8 8.92e-07 1.8 8.921e-07 1.8 8.96e-07 1.8 8.961e-07 1.8 9e-07 1.8 9.001e-07 1.8 9.04e-07 1.8 9.041e-07 1.8 9.08e-07 1.8 9.081e-07 1.8 9.12e-07 1.8 9.121e-07 1.8 9.16e-07 1.8 9.161e-07 1.8 9.2e-07 1.8 9.201e-07 1.8 9.24e-07 1.8 9.241e-07 1.8 9.28e-07 1.8 9.281e-07 1.8 9.32e-07 1.8 9.321e-07 1.8 9.36e-07 1.8 9.361e-07 1.8 9.4e-07 1.8 9.401e-07 1.8 9.44e-07 1.8 9.441e-07 1.8 9.48e-07 1.8 9.481e-07 1.8 9.52e-07 1.8 9.521e-07 1.8 9.56e-07 1.8 9.56e-07 1.8 9.6e-07 1.8 9.601e-07 1.8 9.64e-07 1.8 9.64e-07 1.8 9.68e-07 1.8 9.68e-07 1.8 9.72e-07 1.8 9.72e-07 1.8 9.76e-07 1.8 9.76e-07 1.8 9.8e-07 1.8 9.801e-07 1.8 9.84e-07 1.8 9.84e-07 1.8 9.88e-07 1.8 9.881e-07 1.8 9.92e-07 1.8 9.92e-07 1.8 9.96e-07 1.8 9.96e-07 1.8 1e-06 1.8 1e-06 1.8 1.004e-06 1.8 1.004e-06 1.8 1.008e-06 1.8 1.008e-06 1.8 1.012e-06 1.8 1.012e-06 1.8 1.016e-06 1.8 1.016e-06 1.8 1.02e-06 1.8 1.02e-06 1.8 1.024e-06 1.8 1.024e-06 0 1.028e-06 0 1.028e-06 0 1.032e-06 0 1.032e-06 0 1.036e-06 0 1.036e-06 0)
VS3 S3 0 PWL(0 0 4e-09 0 4.05e-09 0 8e-09 0 8.05e-09 0 1.2e-08 0 1.205e-08 0 1.6e-08 0 1.605e-08 0 2e-08 0 2.005e-08 0 2.4e-08 0 2.405e-08 0 2.8e-08 0 2.805e-08 0 3.2e-08 0 3.205e-08 0 3.6e-08 0 3.605e-08 0 4e-08 0 4.005e-08 0 4.4e-08 0 4.405e-08 0 4.8e-08 0 4.805e-08 0 5.2e-08 0 5.205e-08 0 5.6e-08 0 5.605e-08 0 6e-08 0 6.005e-08 0 6.4e-08 0 6.405e-08 0 6.8e-08 0 6.805e-08 0 7.2e-08 0 7.205e-08 0 7.6e-08 0 7.605e-08 0 8e-08 0 8.005e-08 0 8.4e-08 0 8.405e-08 0 8.8e-08 0 8.805e-08 0 9.2e-08 0 9.205e-08 0 9.6e-08 0 9.605e-08 0 1e-07 0 1.001e-07 0 1.04e-07 0 1.041e-07 0 1.08e-07 0 1.081e-07 0 1.12e-07 0 1.121e-07 0 1.16e-07 0 1.161e-07 0 1.2e-07 0 1.201e-07 0 1.24e-07 0 1.241e-07 0 1.28e-07 0 1.281e-07 0 1.32e-07 0 1.321e-07 0 1.36e-07 0 1.361e-07 0 1.4e-07 0 1.401e-07 0 1.44e-07 0 1.441e-07 0 1.48e-07 0 1.481e-07 0 1.52e-07 0 1.521e-07 0 1.56e-07 0 1.561e-07 0 1.6e-07 0 1.601e-07 0 1.64e-07 0 1.641e-07 0 1.68e-07 0 1.681e-07 0 1.72e-07 0 1.721e-07 0 1.76e-07 0 1.761e-07 0 1.8e-07 0 1.801e-07 0 1.84e-07 0 1.841e-07 0 1.88e-07 0 1.881e-07 0 1.92e-07 0 1.921e-07 0 1.96e-07 0 1.961e-07 0 2e-07 0 2.001e-07 0 2.04e-07 0 2.041e-07 0 2.08e-07 0 2.081e-07 0 2.12e-07 0 2.121e-07 0 2.16e-07 0 2.161e-07 0 2.2e-07 0 2.201e-07 0 2.24e-07 0 2.241e-07 0 2.28e-07 0 2.281e-07 0 2.32e-07 0 2.321e-07 0 2.36e-07 0 2.361e-07 0 2.4e-07 0 2.401e-07 0 2.44e-07 0 2.441e-07 0 2.48e-07 0 2.481e-07 0 2.52e-07 0 2.521e-07 0 2.56e-07 0 2.561e-07 0 2.6e-07 0 2.601e-07 0 2.64e-07 0 2.641e-07 0 2.68e-07 0 2.681e-07 0 2.72e-07 0 2.721e-07 0 2.76e-07 0 2.761e-07 0 2.8e-07 0 2.801e-07 0 2.84e-07 0 2.841e-07 0 2.88e-07 0 2.881e-07 0 2.92e-07 0 2.921e-07 0 2.96e-07 0 2.961e-07 0 3e-07 0 3.001e-07 0 3.04e-07 0 3.041e-07 0 3.08e-07 0 3.081e-07 0 3.12e-07 0 3.121e-07 0 3.16e-07 0 3.161e-07 0 3.2e-07 0 3.201e-07 0 3.24e-07 0 3.241e-07 0 3.28e-07 0 3.281e-07 0 3.32e-07 0 3.321e-07 0 3.36e-07 0 3.361e-07 0 3.4e-07 0 3.401e-07 0 3.44e-07 0 3.441e-07 0 3.48e-07 0 3.481e-07 0 3.52e-07 0 3.521e-07 0 3.56e-07 0 3.561e-07 0 3.6e-07 0 3.601e-07 0 3.64e-07 0 3.641e-07 0 3.68e-07 0 3.681e-07 0 3.72e-07 0 3.721e-07 0 3.76e-07 0 3.761e-07 0 3.8e-07 0 3.801e-07 0 3.84e-07 0 3.841e-07 0 3.88e-07 0 3.881e-07 0 3.92e-07 0 3.921e-07 0 3.96e-07 0 3.961e-07 0 4e-07 0 4.001e-07 0 4.04e-07 0 4.041e-07 0 4.08e-07 0 4.081e-07 0 4.12e-07 0 4.121e-07 0 4.16e-07 0 4.161e-07 0 4.2e-07 0 4.201e-07 0 4.24e-07 0 4.241e-07 0 4.28e-07 0 4.281e-07 0 4.32e-07 0 4.321e-07 0 4.36e-07 0 4.361e-07 0 4.4e-07 0 4.401e-07 0 4.44e-07 0 4.441e-07 0 4.48e-07 0 4.481e-07 0 4.52e-07 0 4.521e-07 0 4.56e-07 0 4.561e-07 0 4.6e-07 0 4.601e-07 0 4.64e-07 0 4.641e-07 0 4.68e-07 0 4.681e-07 0 4.72e-07 0 4.721e-07 0 4.76e-07 0 4.761e-07 0 4.8e-07 0 4.801e-07 0 4.84e-07 0 4.841e-07 0 4.88e-07 0 4.881e-07 0 4.92e-07 0 4.921e-07 0 4.96e-07 0 4.96e-07 0 5e-07 0 5.001e-07 0 5.04e-07 0 5.041e-07 0 5.08e-07 0 5.081e-07 0 5.12e-07 0 5.121e-07 1.8 5.16e-07 1.8 5.161e-07 1.8 5.2e-07 1.8 5.201e-07 1.8 5.24e-07 1.8 5.24e-07 1.8 5.28e-07 1.8 5.281e-07 1.8 5.32e-07 1.8 5.321e-07 1.8 5.36e-07 1.8 5.361e-07 1.8 5.4e-07 1.8 5.401e-07 1.8 5.44e-07 1.8 5.441e-07 1.8 5.48e-07 1.8 5.48e-07 1.8 5.52e-07 1.8 5.521e-07 1.8 5.56e-07 1.8 5.561e-07 1.8 5.6e-07 1.8 5.601e-07 1.8 5.64e-07 1.8 5.641e-07 1.8 5.68e-07 1.8 5.681e-07 1.8 5.72e-07 1.8 5.72e-07 1.8 5.76e-07 1.8 5.761e-07 1.8 5.8e-07 1.8 5.801e-07 1.8 5.84e-07 1.8 5.841e-07 1.8 5.88e-07 1.8 5.881e-07 1.8 5.92e-07 1.8 5.921e-07 1.8 5.96e-07 1.8 5.96e-07 1.8 6e-07 1.8 6.001e-07 1.8 6.04e-07 1.8 6.041e-07 1.8 6.08e-07 1.8 6.081e-07 1.8 6.12e-07 1.8 6.121e-07 1.8 6.16e-07 1.8 6.161e-07 1.8 6.2e-07 1.8 6.2e-07 1.8 6.24e-07 1.8 6.241e-07 1.8 6.28e-07 1.8 6.281e-07 1.8 6.32e-07 1.8 6.321e-07 1.8 6.36e-07 1.8 6.361e-07 1.8 6.4e-07 1.8 6.401e-07 1.8 6.44e-07 1.8 6.441e-07 1.8 6.48e-07 1.8 6.481e-07 1.8 6.52e-07 1.8 6.521e-07 1.8 6.56e-07 1.8 6.561e-07 1.8 6.6e-07 1.8 6.601e-07 1.8 6.64e-07 1.8 6.641e-07 1.8 6.68e-07 1.8 6.681e-07 1.8 6.72e-07 1.8 6.721e-07 1.8 6.76e-07 1.8 6.761e-07 1.8 6.8e-07 1.8 6.801e-07 1.8 6.84e-07 1.8 6.841e-07 1.8 6.88e-07 1.8 6.881e-07 1.8 6.92e-07 1.8 6.921e-07 1.8 6.96e-07 1.8 6.961e-07 1.8 7e-07 1.8 7.001e-07 1.8 7.04e-07 1.8 7.041e-07 1.8 7.08e-07 1.8 7.081e-07 1.8 7.12e-07 1.8 7.121e-07 1.8 7.16e-07 1.8 7.161e-07 1.8 7.2e-07 1.8 7.201e-07 1.8 7.24e-07 1.8 7.241e-07 1.8 7.28e-07 1.8 7.281e-07 1.8 7.32e-07 1.8 7.321e-07 1.8 7.36e-07 1.8 7.361e-07 1.8 7.4e-07 1.8 7.401e-07 1.8 7.44e-07 1.8 7.441e-07 1.8 7.48e-07 1.8 7.481e-07 1.8 7.52e-07 1.8 7.521e-07 1.8 7.56e-07 1.8 7.561e-07 1.8 7.6e-07 1.8 7.601e-07 1.8 7.64e-07 1.8 7.641e-07 1.8 7.68e-07 1.8 7.681e-07 1.8 7.72e-07 1.8 7.721e-07 1.8 7.76e-07 1.8 7.761e-07 1.8 7.8e-07 1.8 7.801e-07 1.8 7.84e-07 1.8 7.841e-07 1.8 7.88e-07 1.8 7.881e-07 1.8 7.92e-07 1.8 7.921e-07 1.8 7.96e-07 1.8 7.961e-07 1.8 8e-07 1.8 8.001e-07 1.8 8.04e-07 1.8 8.041e-07 1.8 8.08e-07 1.8 8.081e-07 1.8 8.12e-07 1.8 8.121e-07 1.8 8.16e-07 1.8 8.161e-07 1.8 8.2e-07 1.8 8.201e-07 1.8 8.24e-07 1.8 8.241e-07 1.8 8.28e-07 1.8 8.281e-07 1.8 8.32e-07 1.8 8.321e-07 1.8 8.36e-07 1.8 8.361e-07 1.8 8.4e-07 1.8 8.401e-07 1.8 8.44e-07 1.8 8.441e-07 1.8 8.48e-07 1.8 8.481e-07 1.8 8.52e-07 1.8 8.521e-07 1.8 8.56e-07 1.8 8.561e-07 1.8 8.6e-07 1.8 8.601e-07 1.8 8.64e-07 1.8 8.641e-07 1.8 8.68e-07 1.8 8.681e-07 1.8 8.72e-07 1.8 8.721e-07 1.8 8.76e-07 1.8 8.761e-07 1.8 8.8e-07 1.8 8.801e-07 1.8 8.84e-07 1.8 8.841e-07 1.8 8.88e-07 1.8 8.881e-07 1.8 8.92e-07 1.8 8.921e-07 1.8 8.96e-07 1.8 8.961e-07 1.8 9e-07 1.8 9.001e-07 1.8 9.04e-07 1.8 9.041e-07 1.8 9.08e-07 1.8 9.081e-07 1.8 9.12e-07 1.8 9.121e-07 1.8 9.16e-07 1.8 9.161e-07 1.8 9.2e-07 1.8 9.201e-07 1.8 9.24e-07 1.8 9.241e-07 1.8 9.28e-07 1.8 9.281e-07 1.8 9.32e-07 1.8 9.321e-07 1.8 9.36e-07 1.8 9.361e-07 1.8 9.4e-07 1.8 9.401e-07 1.8 9.44e-07 1.8 9.441e-07 1.8 9.48e-07 1.8 9.481e-07 1.8 9.52e-07 1.8 9.521e-07 1.8 9.56e-07 1.8 9.56e-07 1.8 9.6e-07 1.8 9.601e-07 1.8 9.64e-07 1.8 9.64e-07 1.8 9.68e-07 1.8 9.68e-07 1.8 9.72e-07 1.8 9.72e-07 1.8 9.76e-07 1.8 9.76e-07 1.8 9.8e-07 1.8 9.801e-07 1.8 9.84e-07 1.8 9.84e-07 1.8 9.88e-07 1.8 9.881e-07 1.8 9.92e-07 1.8 9.92e-07 1.8 9.96e-07 1.8 9.96e-07 1.8 1e-06 1.8 1e-06 1.8 1.004e-06 1.8 1.004e-06 1.8 1.008e-06 1.8 1.008e-06 1.8 1.012e-06 1.8 1.012e-06 1.8 1.016e-06 1.8 1.016e-06 1.8 1.02e-06 1.8 1.02e-06 1.8 1.024e-06 1.8 1.024e-06 1.8 1.028e-06 1.8 1.028e-06 1.8 1.032e-06 1.8 1.032e-06 1.8 1.036e-06 1.8 1.036e-06 1.8)
VM M 0 PWL(0 0 4e-09 0 4.05e-09 0 8e-09 0 8.05e-09 0 1.2e-08 0 1.205e-08 0 1.6e-08 0 1.605e-08 0 2e-08 0 2.005e-08 0 2.4e-08 0 2.405e-08 0 2.8e-08 0 2.805e-08 0 3.2e-08 0 3.205e-08 1.8 3.6e-08 1.8 3.605e-08 1.8 4e-08 1.8 4.005e-08 1.8 4.4e-08 1.8 4.405e-08 1.8 4.8e-08 1.8 4.805e-08 1.8 5.2e-08 1.8 5.205e-08 1.8 5.6e-08 1.8 5.605e-08 1.8 6e-08 1.8 6.005e-08 1.8 6.4e-08 1.8 6.405e-08 0 6.8e-08 0 6.805e-08 0 7.2e-08 0 7.205e-08 0 7.6e-08 0 7.605e-08 0 8e-08 0 8.005e-08 0 8.4e-08 0 8.405e-08 0 8.8e-08 0 8.805e-08 0 9.2e-08 0 9.205e-08 0 9.6e-08 0 9.605e-08 1.8 1e-07 1.8 1.001e-07 1.8 1.04e-07 1.8 1.041e-07 1.8 1.08e-07 1.8 1.081e-07 1.8 1.12e-07 1.8 1.121e-07 1.8 1.16e-07 1.8 1.161e-07 1.8 1.2e-07 1.8 1.201e-07 1.8 1.24e-07 1.8 1.241e-07 1.8 1.28e-07 1.8 1.281e-07 0 1.32e-07 0 1.321e-07 0 1.36e-07 0 1.361e-07 0 1.4e-07 0 1.401e-07 0 1.44e-07 0 1.441e-07 0 1.48e-07 0 1.481e-07 0 1.52e-07 0 1.521e-07 0 1.56e-07 0 1.561e-07 0 1.6e-07 0 1.601e-07 1.8 1.64e-07 1.8 1.641e-07 1.8 1.68e-07 1.8 1.681e-07 1.8 1.72e-07 1.8 1.721e-07 1.8 1.76e-07 1.8 1.761e-07 1.8 1.8e-07 1.8 1.801e-07 1.8 1.84e-07 1.8 1.841e-07 1.8 1.88e-07 1.8 1.881e-07 1.8 1.92e-07 1.8 1.921e-07 0 1.96e-07 0 1.961e-07 0 2e-07 0 2.001e-07 0 2.04e-07 0 2.041e-07 0 2.08e-07 0 2.081e-07 0 2.12e-07 0 2.121e-07 0 2.16e-07 0 2.161e-07 0 2.2e-07 0 2.201e-07 0 2.24e-07 0 2.241e-07 1.8 2.28e-07 1.8 2.281e-07 1.8 2.32e-07 1.8 2.321e-07 1.8 2.36e-07 1.8 2.361e-07 1.8 2.4e-07 1.8 2.401e-07 1.8 2.44e-07 1.8 2.441e-07 1.8 2.48e-07 1.8 2.481e-07 1.8 2.52e-07 1.8 2.521e-07 1.8 2.56e-07 1.8 2.561e-07 0 2.6e-07 0 2.601e-07 0 2.64e-07 0 2.641e-07 0 2.68e-07 0 2.681e-07 0 2.72e-07 0 2.721e-07 0 2.76e-07 0 2.761e-07 0 2.8e-07 0 2.801e-07 0 2.84e-07 0 2.841e-07 0 2.88e-07 0 2.881e-07 1.8 2.92e-07 1.8 2.921e-07 1.8 2.96e-07 1.8 2.961e-07 1.8 3e-07 1.8 3.001e-07 1.8 3.04e-07 1.8 3.041e-07 1.8 3.08e-07 1.8 3.081e-07 1.8 3.12e-07 1.8 3.121e-07 1.8 3.16e-07 1.8 3.161e-07 1.8 3.2e-07 1.8 3.201e-07 0 3.24e-07 0 3.241e-07 0 3.28e-07 0 3.281e-07 0 3.32e-07 0 3.321e-07 0 3.36e-07 0 3.361e-07 0 3.4e-07 0 3.401e-07 0 3.44e-07 0 3.441e-07 0 3.48e-07 0 3.481e-07 0 3.52e-07 0 3.521e-07 1.8 3.56e-07 1.8 3.561e-07 1.8 3.6e-07 1.8 3.601e-07 1.8 3.64e-07 1.8 3.641e-07 1.8 3.68e-07 1.8 3.681e-07 1.8 3.72e-07 1.8 3.721e-07 1.8 3.76e-07 1.8 3.761e-07 1.8 3.8e-07 1.8 3.801e-07 1.8 3.84e-07 1.8 3.841e-07 0 3.88e-07 0 3.881e-07 0 3.92e-07 0 3.921e-07 0 3.96e-07 0 3.961e-07 0 4e-07 0 4.001e-07 0 4.04e-07 0 4.041e-07 0 4.08e-07 0 4.081e-07 0 4.12e-07 0 4.121e-07 0 4.16e-07 0 4.161e-07 1.8 4.2e-07 1.8 4.201e-07 1.8 4.24e-07 1.8 4.241e-07 1.8 4.28e-07 1.8 4.281e-07 1.8 4.32e-07 1.8 4.321e-07 1.8 4.36e-07 1.8 4.361e-07 1.8 4.4e-07 1.8 4.401e-07 1.8 4.44e-07 1.8 4.441e-07 1.8 4.48e-07 1.8 4.481e-07 0 4.52e-07 0 4.521e-07 0 4.56e-07 0 4.561e-07 0 4.6e-07 0 4.601e-07 0 4.64e-07 0 4.641e-07 0 4.68e-07 0 4.681e-07 0 4.72e-07 0 4.721e-07 0 4.76e-07 0 4.761e-07 0 4.8e-07 0 4.801e-07 1.8 4.84e-07 1.8 4.841e-07 1.8 4.88e-07 1.8 4.881e-07 1.8 4.92e-07 1.8 4.921e-07 1.8 4.96e-07 1.8 4.96e-07 1.8 5e-07 1.8 5.001e-07 1.8 5.04e-07 1.8 5.041e-07 1.8 5.08e-07 1.8 5.081e-07 1.8 5.12e-07 1.8 5.121e-07 0 5.16e-07 0 5.161e-07 0 5.2e-07 0 5.201e-07 0 5.24e-07 0 5.24e-07 0 5.28e-07 0 5.281e-07 0 5.32e-07 0 5.321e-07 0 5.36e-07 0 5.361e-07 0 5.4e-07 0 5.401e-07 0 5.44e-07 0 5.441e-07 1.8 5.48e-07 1.8 5.48e-07 1.8 5.52e-07 1.8 5.521e-07 1.8 5.56e-07 1.8 5.561e-07 1.8 5.6e-07 1.8 5.601e-07 1.8 5.64e-07 1.8 5.641e-07 1.8 5.68e-07 1.8 5.681e-07 1.8 5.72e-07 1.8 5.72e-07 1.8 5.76e-07 1.8 5.761e-07 0 5.8e-07 0 5.801e-07 0 5.84e-07 0 5.841e-07 0 5.88e-07 0 5.881e-07 0 5.92e-07 0 5.921e-07 0 5.96e-07 0 5.96e-07 0 6e-07 0 6.001e-07 0 6.04e-07 0 6.041e-07 0 6.08e-07 0 6.081e-07 1.8 6.12e-07 1.8 6.121e-07 1.8 6.16e-07 1.8 6.161e-07 1.8 6.2e-07 1.8 6.2e-07 1.8 6.24e-07 1.8 6.241e-07 1.8 6.28e-07 1.8 6.281e-07 1.8 6.32e-07 1.8 6.321e-07 1.8 6.36e-07 1.8 6.361e-07 1.8 6.4e-07 1.8 6.401e-07 0 6.44e-07 0 6.441e-07 0 6.48e-07 0 6.481e-07 0 6.52e-07 0 6.521e-07 0 6.56e-07 0 6.561e-07 0 6.6e-07 0 6.601e-07 0 6.64e-07 0 6.641e-07 0 6.68e-07 0 6.681e-07 0 6.72e-07 0 6.721e-07 1.8 6.76e-07 1.8 6.761e-07 1.8 6.8e-07 1.8 6.801e-07 1.8 6.84e-07 1.8 6.841e-07 1.8 6.88e-07 1.8 6.881e-07 1.8 6.92e-07 1.8 6.921e-07 1.8 6.96e-07 1.8 6.961e-07 1.8 7e-07 1.8 7.001e-07 1.8 7.04e-07 1.8 7.041e-07 0 7.08e-07 0 7.081e-07 0 7.12e-07 0 7.121e-07 0 7.16e-07 0 7.161e-07 0 7.2e-07 0 7.201e-07 0 7.24e-07 0 7.241e-07 0 7.28e-07 0 7.281e-07 0 7.32e-07 0 7.321e-07 0 7.36e-07 0 7.361e-07 1.8 7.4e-07 1.8 7.401e-07 1.8 7.44e-07 1.8 7.441e-07 1.8 7.48e-07 1.8 7.481e-07 1.8 7.52e-07 1.8 7.521e-07 1.8 7.56e-07 1.8 7.561e-07 1.8 7.6e-07 1.8 7.601e-07 1.8 7.64e-07 1.8 7.641e-07 1.8 7.68e-07 1.8 7.681e-07 0 7.72e-07 0 7.721e-07 0 7.76e-07 0 7.761e-07 0 7.8e-07 0 7.801e-07 0 7.84e-07 0 7.841e-07 0 7.88e-07 0 7.881e-07 0 7.92e-07 0 7.921e-07 0 7.96e-07 0 7.961e-07 0 8e-07 0 8.001e-07 1.8 8.04e-07 1.8 8.041e-07 1.8 8.08e-07 1.8 8.081e-07 1.8 8.12e-07 1.8 8.121e-07 1.8 8.16e-07 1.8 8.161e-07 1.8 8.2e-07 1.8 8.201e-07 1.8 8.24e-07 1.8 8.241e-07 1.8 8.28e-07 1.8 8.281e-07 1.8 8.32e-07 1.8 8.321e-07 0 8.36e-07 0 8.361e-07 0 8.4e-07 0 8.401e-07 0 8.44e-07 0 8.441e-07 0 8.48e-07 0 8.481e-07 0 8.52e-07 0 8.521e-07 0 8.56e-07 0 8.561e-07 0 8.6e-07 0 8.601e-07 0 8.64e-07 0 8.641e-07 1.8 8.68e-07 1.8 8.681e-07 1.8 8.72e-07 1.8 8.721e-07 1.8 8.76e-07 1.8 8.761e-07 1.8 8.8e-07 1.8 8.801e-07 1.8 8.84e-07 1.8 8.841e-07 1.8 8.88e-07 1.8 8.881e-07 1.8 8.92e-07 1.8 8.921e-07 1.8 8.96e-07 1.8 8.961e-07 0 9e-07 0 9.001e-07 0 9.04e-07 0 9.041e-07 0 9.08e-07 0 9.081e-07 0 9.12e-07 0 9.121e-07 0 9.16e-07 0 9.161e-07 0 9.2e-07 0 9.201e-07 0 9.24e-07 0 9.241e-07 0 9.28e-07 0 9.281e-07 1.8 9.32e-07 1.8 9.321e-07 1.8 9.36e-07 1.8 9.361e-07 1.8 9.4e-07 1.8 9.401e-07 1.8 9.44e-07 1.8 9.441e-07 1.8 9.48e-07 1.8 9.481e-07 1.8 9.52e-07 1.8 9.521e-07 1.8 9.56e-07 1.8 9.56e-07 1.8 9.6e-07 1.8 9.601e-07 0 9.64e-07 0 9.64e-07 0 9.68e-07 0 9.68e-07 0 9.72e-07 0 9.72e-07 0 9.76e-07 0 9.76e-07 0 9.8e-07 0 9.801e-07 0 9.84e-07 0 9.84e-07 0 9.88e-07 0 9.881e-07 0 9.92e-07 0 9.92e-07 1.8 9.96e-07 1.8 9.96e-07 1.8 1e-06 1.8 1e-06 1.8 1.004e-06 1.8 1.004e-06 1.8 1.008e-06 1.8 1.008e-06 1.8 1.012e-06 1.8 1.012e-06 1.8 1.016e-06 1.8 1.016e-06 1.8 1.02e-06 1.8 1.02e-06 1.8 1.024e-06 1.8 1.024e-06 0 1.028e-06 0 1.028e-06 0 1.032e-06 0 1.032e-06 0 1.036e-06 0 1.036e-06 0)
VCn Cn 0 PWL(0 1.8 4e-09 1.8 4.05e-09 1.8 8e-09 1.8 8.05e-09 1.8 1.2e-08 1.8 1.205e-08 1.8 1.6e-08 1.8 1.605e-08 0 2e-08 0 2.005e-08 0 2.4e-08 0 2.405e-08 0 2.8e-08 0 2.805e-08 0 3.2e-08 0 3.205e-08 1.8 3.6e-08 1.8 3.605e-08 1.8 4e-08 1.8 4.005e-08 1.8 4.4e-08 1.8 4.405e-08 1.8 4.8e-08 1.8 4.805e-08 0 5.2e-08 0 5.205e-08 0 5.6e-08 0 5.605e-08 0 6e-08 0 6.005e-08 0 6.4e-08 0 6.405e-08 1.8 6.8e-08 1.8 6.805e-08 1.8 7.2e-08 1.8 7.205e-08 1.8 7.6e-08 1.8 7.605e-08 1.8 8e-08 1.8 8.005e-08 0 8.4e-08 0 8.405e-08 0 8.8e-08 0 8.805e-08 0 9.2e-08 0 9.205e-08 0 9.6e-08 0 9.605e-08 1.8 1e-07 1.8 1.001e-07 1.8 1.04e-07 1.8 1.041e-07 1.8 1.08e-07 1.8 1.081e-07 1.8 1.12e-07 1.8 1.121e-07 0 1.16e-07 0 1.161e-07 0 1.2e-07 0 1.201e-07 0 1.24e-07 0 1.241e-07 0 1.28e-07 0 1.281e-07 1.8 1.32e-07 1.8 1.321e-07 1.8 1.36e-07 1.8 1.361e-07 1.8 1.4e-07 1.8 1.401e-07 1.8 1.44e-07 1.8 1.441e-07 0 1.48e-07 0 1.481e-07 0 1.52e-07 0 1.521e-07 0 1.56e-07 0 1.561e-07 0 1.6e-07 0 1.601e-07 1.8 1.64e-07 1.8 1.641e-07 1.8 1.68e-07 1.8 1.681e-07 1.8 1.72e-07 1.8 1.721e-07 1.8 1.76e-07 1.8 1.761e-07 0 1.8e-07 0 1.801e-07 0 1.84e-07 0 1.841e-07 0 1.88e-07 0 1.881e-07 0 1.92e-07 0 1.921e-07 1.8 1.96e-07 1.8 1.961e-07 1.8 2e-07 1.8 2.001e-07 1.8 2.04e-07 1.8 2.041e-07 1.8 2.08e-07 1.8 2.081e-07 0 2.12e-07 0 2.121e-07 0 2.16e-07 0 2.161e-07 0 2.2e-07 0 2.201e-07 0 2.24e-07 0 2.241e-07 1.8 2.28e-07 1.8 2.281e-07 1.8 2.32e-07 1.8 2.321e-07 1.8 2.36e-07 1.8 2.361e-07 1.8 2.4e-07 1.8 2.401e-07 0 2.44e-07 0 2.441e-07 0 2.48e-07 0 2.481e-07 0 2.52e-07 0 2.521e-07 0 2.56e-07 0 2.561e-07 1.8 2.6e-07 1.8 2.601e-07 1.8 2.64e-07 1.8 2.641e-07 1.8 2.68e-07 1.8 2.681e-07 1.8 2.72e-07 1.8 2.721e-07 0 2.76e-07 0 2.761e-07 0 2.8e-07 0 2.801e-07 0 2.84e-07 0 2.841e-07 0 2.88e-07 0 2.881e-07 1.8 2.92e-07 1.8 2.921e-07 1.8 2.96e-07 1.8 2.961e-07 1.8 3e-07 1.8 3.001e-07 1.8 3.04e-07 1.8 3.041e-07 0 3.08e-07 0 3.081e-07 0 3.12e-07 0 3.121e-07 0 3.16e-07 0 3.161e-07 0 3.2e-07 0 3.201e-07 1.8 3.24e-07 1.8 3.241e-07 1.8 3.28e-07 1.8 3.281e-07 1.8 3.32e-07 1.8 3.321e-07 1.8 3.36e-07 1.8 3.361e-07 0 3.4e-07 0 3.401e-07 0 3.44e-07 0 3.441e-07 0 3.48e-07 0 3.481e-07 0 3.52e-07 0 3.521e-07 1.8 3.56e-07 1.8 3.561e-07 1.8 3.6e-07 1.8 3.601e-07 1.8 3.64e-07 1.8 3.641e-07 1.8 3.68e-07 1.8 3.681e-07 0 3.72e-07 0 3.721e-07 0 3.76e-07 0 3.761e-07 0 3.8e-07 0 3.801e-07 0 3.84e-07 0 3.841e-07 1.8 3.88e-07 1.8 3.881e-07 1.8 3.92e-07 1.8 3.921e-07 1.8 3.96e-07 1.8 3.961e-07 1.8 4e-07 1.8 4.001e-07 0 4.04e-07 0 4.041e-07 0 4.08e-07 0 4.081e-07 0 4.12e-07 0 4.121e-07 0 4.16e-07 0 4.161e-07 1.8 4.2e-07 1.8 4.201e-07 1.8 4.24e-07 1.8 4.241e-07 1.8 4.28e-07 1.8 4.281e-07 1.8 4.32e-07 1.8 4.321e-07 0 4.36e-07 0 4.361e-07 0 4.4e-07 0 4.401e-07 0 4.44e-07 0 4.441e-07 0 4.48e-07 0 4.481e-07 1.8 4.52e-07 1.8 4.521e-07 1.8 4.56e-07 1.8 4.561e-07 1.8 4.6e-07 1.8 4.601e-07 1.8 4.64e-07 1.8 4.641e-07 0 4.68e-07 0 4.681e-07 0 4.72e-07 0 4.721e-07 0 4.76e-07 0 4.761e-07 0 4.8e-07 0 4.801e-07 1.8 4.84e-07 1.8 4.841e-07 1.8 4.88e-07 1.8 4.881e-07 1.8 4.92e-07 1.8 4.921e-07 1.8 4.96e-07 1.8 4.96e-07 0 5e-07 0 5.001e-07 0 5.04e-07 0 5.041e-07 0 5.08e-07 0 5.081e-07 0 5.12e-07 0 5.121e-07 1.8 5.16e-07 1.8 5.161e-07 1.8 5.2e-07 1.8 5.201e-07 1.8 5.24e-07 1.8 5.24e-07 1.8 5.28e-07 1.8 5.281e-07 0 5.32e-07 0 5.321e-07 0 5.36e-07 0 5.361e-07 0 5.4e-07 0 5.401e-07 0 5.44e-07 0 5.441e-07 1.8 5.48e-07 1.8 5.48e-07 1.8 5.52e-07 1.8 5.521e-07 1.8 5.56e-07 1.8 5.561e-07 1.8 5.6e-07 1.8 5.601e-07 0 5.64e-07 0 5.641e-07 0 5.68e-07 0 5.681e-07 0 5.72e-07 0 5.72e-07 0 5.76e-07 0 5.761e-07 1.8 5.8e-07 1.8 5.801e-07 1.8 5.84e-07 1.8 5.841e-07 1.8 5.88e-07 1.8 5.881e-07 1.8 5.92e-07 1.8 5.921e-07 0 5.96e-07 0 5.96e-07 0 6e-07 0 6.001e-07 0 6.04e-07 0 6.041e-07 0 6.08e-07 0 6.081e-07 1.8 6.12e-07 1.8 6.121e-07 1.8 6.16e-07 1.8 6.161e-07 1.8 6.2e-07 1.8 6.2e-07 1.8 6.24e-07 1.8 6.241e-07 0 6.28e-07 0 6.281e-07 0 6.32e-07 0 6.321e-07 0 6.36e-07 0 6.361e-07 0 6.4e-07 0 6.401e-07 1.8 6.44e-07 1.8 6.441e-07 1.8 6.48e-07 1.8 6.481e-07 1.8 6.52e-07 1.8 6.521e-07 1.8 6.56e-07 1.8 6.561e-07 0 6.6e-07 0 6.601e-07 0 6.64e-07 0 6.641e-07 0 6.68e-07 0 6.681e-07 0 6.72e-07 0 6.721e-07 1.8 6.76e-07 1.8 6.761e-07 1.8 6.8e-07 1.8 6.801e-07 1.8 6.84e-07 1.8 6.841e-07 1.8 6.88e-07 1.8 6.881e-07 0 6.92e-07 0 6.921e-07 0 6.96e-07 0 6.961e-07 0 7e-07 0 7.001e-07 0 7.04e-07 0 7.041e-07 1.8 7.08e-07 1.8 7.081e-07 1.8 7.12e-07 1.8 7.121e-07 1.8 7.16e-07 1.8 7.161e-07 1.8 7.2e-07 1.8 7.201e-07 0 7.24e-07 0 7.241e-07 0 7.28e-07 0 7.281e-07 0 7.32e-07 0 7.321e-07 0 7.36e-07 0 7.361e-07 1.8 7.4e-07 1.8 7.401e-07 1.8 7.44e-07 1.8 7.441e-07 1.8 7.48e-07 1.8 7.481e-07 1.8 7.52e-07 1.8 7.521e-07 0 7.56e-07 0 7.561e-07 0 7.6e-07 0 7.601e-07 0 7.64e-07 0 7.641e-07 0 7.68e-07 0 7.681e-07 1.8 7.72e-07 1.8 7.721e-07 1.8 7.76e-07 1.8 7.761e-07 1.8 7.8e-07 1.8 7.801e-07 1.8 7.84e-07 1.8 7.841e-07 0 7.88e-07 0 7.881e-07 0 7.92e-07 0 7.921e-07 0 7.96e-07 0 7.961e-07 0 8e-07 0 8.001e-07 1.8 8.04e-07 1.8 8.041e-07 1.8 8.08e-07 1.8 8.081e-07 1.8 8.12e-07 1.8 8.121e-07 1.8 8.16e-07 1.8 8.161e-07 0 8.2e-07 0 8.201e-07 0 8.24e-07 0 8.241e-07 0 8.28e-07 0 8.281e-07 0 8.32e-07 0 8.321e-07 1.8 8.36e-07 1.8 8.361e-07 1.8 8.4e-07 1.8 8.401e-07 1.8 8.44e-07 1.8 8.441e-07 1.8 8.48e-07 1.8 8.481e-07 0 8.52e-07 0 8.521e-07 0 8.56e-07 0 8.561e-07 0 8.6e-07 0 8.601e-07 0 8.64e-07 0 8.641e-07 1.8 8.68e-07 1.8 8.681e-07 1.8 8.72e-07 1.8 8.721e-07 1.8 8.76e-07 1.8 8.761e-07 1.8 8.8e-07 1.8 8.801e-07 0 8.84e-07 0 8.841e-07 0 8.88e-07 0 8.881e-07 0 8.92e-07 0 8.921e-07 0 8.96e-07 0 8.961e-07 1.8 9e-07 1.8 9.001e-07 1.8 9.04e-07 1.8 9.041e-07 1.8 9.08e-07 1.8 9.081e-07 1.8 9.12e-07 1.8 9.121e-07 0 9.16e-07 0 9.161e-07 0 9.2e-07 0 9.201e-07 0 9.24e-07 0 9.241e-07 0 9.28e-07 0 9.281e-07 1.8 9.32e-07 1.8 9.321e-07 1.8 9.36e-07 1.8 9.361e-07 1.8 9.4e-07 1.8 9.401e-07 1.8 9.44e-07 1.8 9.441e-07 0 9.48e-07 0 9.481e-07 0 9.52e-07 0 9.521e-07 0 9.56e-07 0 9.56e-07 0 9.6e-07 0 9.601e-07 1.8 9.64e-07 1.8 9.64e-07 1.8 9.68e-07 1.8 9.68e-07 1.8 9.72e-07 1.8 9.72e-07 1.8 9.76e-07 1.8 9.76e-07 0 9.8e-07 0 9.801e-07 0 9.84e-07 0 9.84e-07 0 9.88e-07 0 9.881e-07 0 9.92e-07 0 9.92e-07 1.8 9.96e-07 1.8 9.96e-07 1.8 1e-06 1.8 1e-06 1.8 1.004e-06 1.8 1.004e-06 1.8 1.008e-06 1.8 1.008e-06 0 1.012e-06 0 1.012e-06 0 1.016e-06 0 1.016e-06 0 1.02e-06 0 1.02e-06 0 1.024e-06 0 1.024e-06 1.8 1.028e-06 1.8 1.028e-06 0 1.032e-06 0 1.032e-06 1.8 1.036e-06 1.8 1.036e-06 0)
CF0 F0 0 1e-14
CF1 F1 0 1e-14
CF2 F2 0 1e-14
CF3 F3 0 1e-14
CAEQB AEQB 0 1e-14
CP_N P_N 0 1e-14
CG_N G_N 0 1e-14
CCn4 Cn4 0 1e-14
.option method=gear
.control
tran 10p 1.04e-06
wrdata /home/ellis/EG-LOGIC/examples/alu74181/sky130A/ALU181_sim.dat v(F0) v(F1) v(F2) v(F3) v(AEQB) v(P_N) v(G_N) v(Cn4)
quit
.endc
.end
