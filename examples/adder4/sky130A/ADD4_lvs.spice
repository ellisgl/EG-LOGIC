* NGSPICE file created from ADD4.ext - technology: sky130A

.subckt AND A B Y VDD VSS
X0 Y a_242_n201# VSS VSS sky130_fd_pr__nfet_01v8 ad=0.3185 pd=2.28 as=0.3185 ps=2.28 w=0.65 l=0.15
X1 a_242_n201# B VDD VDD sky130_fd_pr__pfet_01v8 ad=0.285 pd=2.57 as=0.14 ps=1.28 w=1 l=0.15
X2 Y a_242_n201# VDD VDD sky130_fd_pr__pfet_01v8 ad=0.49 pd=2.98 as=0.49 ps=2.98 w=1 l=0.15
X3 a_329_n201# A a_242_n201# VSS sky130_fd_pr__nfet_01v8 ad=0.091 pd=0.93 as=0.18525 ps=1.87 w=0.65 l=0.15
X4 VDD A a_242_n201# VDD sky130_fd_pr__pfet_01v8 ad=0.14 pd=1.28 as=0.285 ps=2.57 w=1 l=0.15
X5 VSS B a_329_n201# VSS sky130_fd_pr__nfet_01v8 ad=0.18525 pd=1.87 as=0.091 ps=0.93 w=0.65 l=0.15
.ends

.subckt XOR A B Y VDD VSS
X0 a_1028_164# B VDD VDD sky130_fd_pr__pfet_01v8 ad=0.2425 pd=1.485 as=0.14 ps=1.28 w=1 l=0.15
X1 Y a_744_n285# VSS VSS sky130_fd_pr__nfet_01v8 ad=0.3185 pd=2.28 as=0.15763 ps=1.135 w=0.65 l=0.15
X2 Y a_744_n285# a_1028_164# VDD sky130_fd_pr__pfet_01v8 ad=0.49 pd=2.98 as=0.2425 ps=1.485 w=1 l=0.15
X3 a_831_164# A a_744_n285# VDD sky130_fd_pr__pfet_01v8 ad=0.14 pd=1.28 as=0.285 ps=2.57 w=1 l=0.15
X4 VDD B a_831_164# VDD sky130_fd_pr__pfet_01v8 ad=0.285 pd=2.57 as=0.14 ps=1.28 w=1 l=0.15
X5 VSS A a_744_n285# VSS sky130_fd_pr__nfet_01v8 ad=0.091 pd=0.93 as=0.18525 ps=1.87 w=0.65 l=0.15
X6 VDD A a_1028_164# VDD sky130_fd_pr__pfet_01v8 ad=0.14 pd=1.28 as=0.285 ps=2.57 w=1 l=0.15
X7 a_744_n285# B VSS VSS sky130_fd_pr__nfet_01v8 ad=0.18525 pd=1.87 as=0.091 ps=0.93 w=0.65 l=0.15
X8 a_1115_n285# A Y VSS sky130_fd_pr__nfet_01v8 ad=0.091 pd=0.93 as=0.18525 ps=1.87 w=0.65 l=0.15
X9 VSS B a_1115_n285# VSS sky130_fd_pr__nfet_01v8 ad=0.15763 pd=1.135 as=0.091 ps=0.93 w=0.65 l=0.15
.ends

.subckt OR A B Y VDD VSS
X0 Y a_407_n201# VDD VDD sky130_fd_pr__pfet_01v8 ad=0.49 pd=2.98 as=0.49 ps=2.98 w=1 l=0.15
X1 VSS A a_407_n201# VSS sky130_fd_pr__nfet_01v8 ad=0.091 pd=0.93 as=0.18525 ps=1.87 w=0.65 l=0.15
X2 a_407_n201# B VSS VSS sky130_fd_pr__nfet_01v8 ad=0.18525 pd=1.87 as=0.091 ps=0.93 w=0.65 l=0.15
X3 VDD B a_494_80# VDD sky130_fd_pr__pfet_01v8 ad=0.285 pd=2.57 as=0.14 ps=1.28 w=1 l=0.15
X4 Y a_407_n201# VSS VSS sky130_fd_pr__nfet_01v8 ad=0.3185 pd=2.28 as=0.3185 ps=2.28 w=0.65 l=0.15
X5 a_494_80# A a_407_n201# VDD sky130_fd_pr__pfet_01v8 ad=0.14 pd=1.28 as=0.285 ps=2.57 w=1 l=0.15
.ends

.subckt ADD4 A0 A1 A2 A3 B0 B1 B2 B3 Cin S0 S1 S2 S3 Cout VDD VSS
XAND_3_3 XOR_3_2/A OR_2_4/Y OR_3_4/B VDD VSS AND
XXOR_2_0 A2 B2 XOR_2_2/A VDD VSS XOR
XAND_1_1 A1 B1 OR_1_4/A VDD VSS AND
XXOR_2_2 XOR_2_2/A OR_1_4/Y S2 VDD VSS XOR
XAND_1_3 XOR_1_2/A OR_0_4/Y OR_1_4/B VDD VSS AND
XXOR_0_0 A0 B0 XOR_0_2/A VDD VSS XOR
XXOR_0_2 XOR_0_2/A Cin S0 VDD VSS XOR
XOR_2_4 OR_2_4/A OR_2_4/B OR_2_4/Y VDD VSS OR
XOR_0_4 OR_0_4/A OR_0_4/B OR_0_4/Y VDD VSS OR
XAND_2_1 A2 B2 OR_2_4/A VDD VSS AND
XXOR_3_0 A3 B3 XOR_3_2/A VDD VSS XOR
XXOR_3_2 XOR_3_2/A OR_2_4/Y S3 VDD VSS XOR
XAND_2_3 XOR_2_2/A OR_1_4/Y OR_2_4/B VDD VSS AND
XAND_0_1 A0 B0 OR_0_4/A VDD VSS AND
XXOR_1_0 A1 B1 XOR_1_2/A VDD VSS XOR
XAND_0_3 XOR_0_2/A Cin OR_0_4/B VDD VSS AND
XXOR_1_2 XOR_1_2/A OR_0_4/Y S1 VDD VSS XOR
XOR_3_4 OR_3_4/A OR_3_4/B Cout VDD VSS OR
XOR_1_4 OR_1_4/A OR_1_4/B OR_1_4/Y VDD VSS OR
XAND_3_1 A3 B3 OR_3_4/A VDD VSS AND
.ends
