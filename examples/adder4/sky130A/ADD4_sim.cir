* ADD4 exhaustive test (sky130A)
.lib /home/ellis/pdk/sky130A/libs.tech/ngspice/sky130.lib.spice tt

* NGSPICE file created from ADD4.ext - technology: sky130A

.subckt AND A B Y VDD VSS a_329_n201# a_242_n201#
X0 Y a_242_n201# VSS VSS sky130_fd_pr__nfet_01v8 ad=0.3185 pd=2.28 as=0.3185 ps=2.28 w=0.65 l=0.15
X1 a_242_n201# B VDD VDD sky130_fd_pr__pfet_01v8 ad=0.285 pd=2.57 as=0.14 ps=1.28 w=1 l=0.15
X2 Y a_242_n201# VDD VDD sky130_fd_pr__pfet_01v8 ad=0.49 pd=2.98 as=0.49 ps=2.98 w=1 l=0.15
X3 a_329_n201# A a_242_n201# VSS sky130_fd_pr__nfet_01v8 ad=0.091 pd=0.93 as=0.18525 ps=1.87 w=0.65 l=0.15
X4 VDD A a_242_n201# VDD sky130_fd_pr__pfet_01v8 ad=0.14 pd=1.28 as=0.285 ps=2.57 w=1 l=0.15
X5 VSS B a_329_n201# VSS sky130_fd_pr__nfet_01v8 ad=0.18525 pd=1.87 as=0.091 ps=0.93 w=0.65 l=0.15
C0 a_242_n201# a_329_n201# 0.00891f
C1 a_242_n201# VDD 0.46374f
C2 a_242_n201# A 0.04393f
C3 a_242_n201# B 0.05604f
C4 a_242_n201# Y 0.05622f
C5 a_329_n201# VDD 0
C6 VDD A 0.38371f
C7 VDD B 0.07775f
C8 VDD Y 0.26158f
C9 A B 0.08477f
C10 A Y 0
C11 B Y 0
C12 Y VSS 0.4237f
C13 B VSS 0.81961f
C14 A VSS 0.40204f
C15 VDD VSS 3.0499f
C16 a_329_n201# VSS 0.01072f
C17 a_242_n201# VSS 0.26506f
.ends

.subckt XOR A B Y VDD VSS li_n59_n770# a_1115_n285# a_1028_164# m1_n59_n770# a_831_164#
+ a_744_n285#
X0 a_1028_164# B VDD VDD sky130_fd_pr__pfet_01v8 ad=0.2425 pd=1.485 as=0.14 ps=1.28 w=1 l=0.15
X1 Y a_744_n285# VSS VSS sky130_fd_pr__nfet_01v8 ad=0.3185 pd=2.28 as=0.15763 ps=1.135 w=0.65 l=0.15
X2 Y a_744_n285# a_1028_164# VDD sky130_fd_pr__pfet_01v8 ad=0.49 pd=2.98 as=0.2425 ps=1.485 w=1 l=0.15
X3 a_831_164# A a_744_n285# VDD sky130_fd_pr__pfet_01v8 ad=0.14 pd=1.28 as=0.285 ps=2.57 w=1 l=0.15
X4 VDD B a_831_164# VDD sky130_fd_pr__pfet_01v8 ad=0.285 pd=2.57 as=0.14 ps=1.28 w=1 l=0.15
X5 VSS A a_744_n285# VSS sky130_fd_pr__nfet_01v8 ad=0.091 pd=0.93 as=0.18525 ps=1.87 w=0.65 l=0.15
X6 VDD A a_1028_164# VDD sky130_fd_pr__pfet_01v8 ad=0.14 pd=1.28 as=0.285 ps=2.57 w=1 l=0.15
X7 a_744_n285# B VSS VSS sky130_fd_pr__nfet_01v8 ad=0.18525 pd=1.87 as=0.091 ps=0.93 w=0.65 l=0.15
X8 a_1115_n285# A Y VSS sky130_fd_pr__nfet_01v8 ad=0.091 pd=0.93 as=0.18525 ps=1.87 w=0.65 l=0.15
X9 VSS B a_1115_n285# VSS sky130_fd_pr__nfet_01v8 ad=0.15763 pd=1.135 as=0.091 ps=0.93 w=0.65 l=0.15
C0 a_744_n285# a_831_164# 0.01081f
C1 a_744_n285# a_1028_164# 0.09179f
C2 a_744_n285# li_n59_n770# 0.0058f
C3 a_744_n285# m1_n59_n770# 0
C4 a_744_n285# VDD 0.34024f
C5 a_744_n285# A 0.0725f
C6 a_744_n285# B 0.12453f
C7 a_744_n285# Y 0.2337f
C8 a_831_164# VDD 0.0156f
C9 a_1028_164# VDD 0.28588f
C10 a_1028_164# A 0.03166f
C11 a_1028_164# B 0.03043f
C12 a_1028_164# Y 0.05886f
C13 a_1115_n285# VDD 0
C14 a_1115_n285# Y 0.00891f
C15 li_n59_n770# m1_n59_n770# 0.64924f
C16 li_n59_n770# VDD 0.08118f
C17 li_n59_n770# A 0.06415f
C18 li_n59_n770# B 0.06302f
C19 m1_n59_n770# VDD 0.12266f
C20 m1_n59_n770# A 0.01731f
C21 m1_n59_n770# B 0.01723f
C22 m1_n59_n770# Y 0
C23 VDD A 0.72297f
C24 VDD B 0.18583f
C25 VDD Y 0.29473f
C26 A B 0.2998f
C27 A Y 0.02289f
C28 B Y 0.0227f
C29 Y VSS 0.62914f
C30 B VSS 1.53202f
C31 A VSS 0.87509f
C32 VDD VSS 4.34098f
C33 m1_n59_n770# VSS 0.71489f
C34 li_n59_n770# VSS 0.91068f
C35 a_1115_n285# VSS 0.00905f
C36 a_1028_164# VSS 0.00166f
C37 a_831_164# VSS 0
C38 a_744_n285# VSS 0.39213f
.ends

.subckt OR A B Y VDD VSS a_407_n201# a_494_80#
X0 Y a_407_n201# VDD VDD sky130_fd_pr__pfet_01v8 ad=0.49 pd=2.98 as=0.49 ps=2.98 w=1 l=0.15
X1 VSS A a_407_n201# VSS sky130_fd_pr__nfet_01v8 ad=0.091 pd=0.93 as=0.18525 ps=1.87 w=0.65 l=0.15
X2 a_407_n201# B VSS VSS sky130_fd_pr__nfet_01v8 ad=0.18525 pd=1.87 as=0.091 ps=0.93 w=0.65 l=0.15
X3 VDD B a_494_80# VDD sky130_fd_pr__pfet_01v8 ad=0.285 pd=2.57 as=0.14 ps=1.28 w=1 l=0.15
X4 Y a_407_n201# VSS VSS sky130_fd_pr__nfet_01v8 ad=0.3185 pd=2.28 as=0.3185 ps=2.28 w=0.65 l=0.15
X5 a_494_80# A a_407_n201# VDD sky130_fd_pr__pfet_01v8 ad=0.14 pd=1.28 as=0.285 ps=2.57 w=1 l=0.15
C0 a_407_n201# a_494_80# 0.01259f
C1 a_407_n201# VDD 0.29532f
C2 a_407_n201# A 0.04371f
C3 a_407_n201# B 0.05381f
C4 a_407_n201# Y 0.05582f
C5 a_494_80# VDD 0.01661f
C6 VDD A 0.39741f
C7 VDD B 0.07601f
C8 VDD Y 0.29718f
C9 A B 0.08856f
C10 A Y 0
C11 B Y 0
C12 Y VSS 0.48496f
C13 B VSS 0.93218f
C14 A VSS 0.48762f
C15 VDD VSS 3.44497f
C16 a_494_80# VSS 0
C17 a_407_n201# VSS 0.38357f
.ends

.subckt ADD4 A0 A1 A2 A3 B0 B1 B2 B3 Cin S0 S1 S2 S3 Cout VDD VSS
XAND_3_3 XOR_3_2/A OR_2_4/Y OR_3_4/B VDD VSS AND_3_3/a_329_n201# AND_3_3/a_242_n201#
+ AND
XXOR_2_0 A2 B2 XOR_2_2/A VDD VSS XOR_2_0/li_n59_n770# XOR_2_0/a_1115_n285# XOR_2_0/a_1028_164#
+ XOR_2_0/m1_n59_n770# XOR_2_0/a_831_164# XOR_2_0/a_744_n285# XOR
XAND_1_1 A1 B1 OR_1_4/A VDD VSS AND_1_1/a_329_n201# AND_1_1/a_242_n201# AND
XXOR_2_2 XOR_2_2/A OR_1_4/Y S2 VDD VSS XOR_2_2/li_n59_n770# XOR_2_2/a_1115_n285# XOR_2_2/a_1028_164#
+ XOR_2_2/m1_n59_n770# XOR_2_2/a_831_164# XOR_2_2/a_744_n285# XOR
XAND_1_3 XOR_1_2/A OR_0_4/Y OR_1_4/B VDD VSS AND_1_3/a_329_n201# AND_1_3/a_242_n201#
+ AND
XXOR_0_0 A0 B0 XOR_0_2/A VDD VSS XOR_0_0/li_n59_n770# XOR_0_0/a_1115_n285# XOR_0_0/a_1028_164#
+ XOR_0_0/m1_n59_n770# XOR_0_0/a_831_164# XOR_0_0/a_744_n285# XOR
XXOR_0_2 XOR_0_2/A Cin S0 VDD VSS XOR_0_2/li_n59_n770# XOR_0_2/a_1115_n285# XOR_0_2/a_1028_164#
+ XOR_0_2/m1_n59_n770# XOR_0_2/a_831_164# XOR_0_2/a_744_n285# XOR
XOR_2_4 OR_2_4/A OR_2_4/B OR_2_4/Y VDD VSS OR_2_4/a_407_n201# OR_2_4/a_494_80# OR
XOR_0_4 OR_0_4/A OR_0_4/B OR_0_4/Y VDD VSS OR_0_4/a_407_n201# OR_0_4/a_494_80# OR
XAND_2_1 A2 B2 OR_2_4/A VDD VSS AND_2_1/a_329_n201# AND_2_1/a_242_n201# AND
XXOR_3_0 A3 B3 XOR_3_2/A VDD VSS XOR_3_0/li_n59_n770# XOR_3_0/a_1115_n285# XOR_3_0/a_1028_164#
+ XOR_3_0/m1_n59_n770# XOR_3_0/a_831_164# XOR_3_0/a_744_n285# XOR
XXOR_3_2 XOR_3_2/A OR_2_4/Y S3 VDD VSS XOR_3_2/li_n59_n770# XOR_3_2/a_1115_n285# XOR_3_2/a_1028_164#
+ XOR_3_2/m1_n59_n770# XOR_3_2/a_831_164# XOR_3_2/a_744_n285# XOR
XAND_2_3 XOR_2_2/A OR_1_4/Y OR_2_4/B VDD VSS AND_2_3/a_329_n201# AND_2_3/a_242_n201#
+ AND
XAND_0_1 A0 B0 OR_0_4/A VDD VSS AND_0_1/a_329_n201# AND_0_1/a_242_n201# AND
XXOR_1_0 A1 B1 XOR_1_2/A VDD VSS XOR_1_0/li_n59_n770# XOR_1_0/a_1115_n285# XOR_1_0/a_1028_164#
+ XOR_1_0/m1_n59_n770# XOR_1_0/a_831_164# XOR_1_0/a_744_n285# XOR
XAND_0_3 XOR_0_2/A Cin OR_0_4/B VDD VSS AND_0_3/a_329_n201# AND_0_3/a_242_n201# AND
XXOR_1_2 XOR_1_2/A OR_0_4/Y S1 VDD VSS XOR_1_2/li_n59_n770# XOR_1_2/a_1115_n285# XOR_1_2/a_1028_164#
+ XOR_1_2/m1_n59_n770# XOR_1_2/a_831_164# XOR_1_2/a_744_n285# XOR
XOR_3_4 OR_3_4/A OR_3_4/B Cout VDD VSS OR_3_4/a_407_n201# OR_3_4/a_494_80# OR
XOR_1_4 OR_1_4/A OR_1_4/B OR_1_4/Y VDD VSS OR_1_4/a_407_n201# OR_1_4/a_494_80# OR
XAND_3_1 A3 B3 OR_3_4/A VDD VSS AND_3_1/a_329_n201# AND_3_1/a_242_n201# AND
C0 AND_3_3/a_242_n201# OR_3_4/B 0
C1 AND_3_3/a_242_n201# VDD 0
C2 AND_3_3/a_242_n201# OR_2_4/Y 0.00563f
C3 AND_3_3/a_242_n201# S3 0.04856f
C4 AND_3_3/a_242_n201# OR_3_4/A 0.01527f
C5 AND_3_3/a_329_n201# OR_2_4/Y 0.00149f
C6 AND_3_3/a_329_n201# S3 0.00202f
C7 OR_3_4/B VDD 0.01093f
C8 OR_3_4/B OR_2_4/Y 0.08475f
C9 OR_3_4/B XOR_3_2/A 0
C10 OR_3_4/B S3 0.42381f
C11 OR_3_4/B OR_3_4/a_407_n201# 0.00368f
C12 OR_3_4/B Cout 0
C13 OR_3_4/B OR_3_4/A 0.08702f
C14 XOR_2_0/a_744_n285# XOR_2_0/m1_n59_n770# 0
C15 XOR_2_0/a_744_n285# A2 0.01788f
C16 XOR_2_0/a_744_n285# B2 0.0177f
C17 XOR_2_0/a_744_n285# XOR_2_2/A 0
C18 XOR_2_0/a_744_n285# VDD 0
C19 XOR_2_0/a_831_164# A2 0.00272f
C20 XOR_2_0/a_831_164# B2 0.00104f
C21 XOR_2_0/a_1028_164# A2 0.01486f
C22 XOR_2_0/a_1028_164# B2 0.0041f
C23 XOR_2_0/a_1115_n285# A2 0
C24 XOR_2_0/a_1115_n285# B2 0.00169f
C25 XOR_2_0/li_n59_n770# A2 0.0103f
C26 XOR_2_0/li_n59_n770# B2 0.01031f
C27 XOR_2_0/li_n59_n770# VDD 0.01324f
C28 XOR_2_0/li_n59_n770# XOR_3_0/li_n59_n770# 0.00538f
C29 XOR_2_0/li_n59_n770# B3 0
C30 XOR_2_0/li_n59_n770# XOR_1_0/li_n59_n770# 0.00539f
C31 XOR_2_0/li_n59_n770# A1 0
C32 XOR_2_0/m1_n59_n770# A2 0.1529f
C33 XOR_2_0/m1_n59_n770# B2 0.15292f
C34 XOR_2_0/m1_n59_n770# VDD 0.03903f
C35 XOR_2_0/m1_n59_n770# XOR_3_0/m1_n59_n770# 0.00913f
C36 XOR_2_0/m1_n59_n770# XOR_1_0/m1_n59_n770# 0.00914f
C37 A2 B2 0.24926f
C38 A2 XOR_2_2/A 0.20552f
C39 A2 VDD 1.0972f
C40 A2 OR_2_4/A 0
C41 A2 XOR_3_0/li_n59_n770# 0
C42 B2 XOR_2_2/A 0.11319f
C43 B2 VDD 0.05773f
C44 B2 OR_2_4/A 0
C45 B2 XOR_1_0/li_n59_n770# 0
C46 XOR_2_2/A XOR_2_2/a_744_n285# 0.0083f
C47 XOR_2_2/A XOR_2_2/a_831_164# 0.00264f
C48 XOR_2_2/A XOR_2_2/a_1028_164# 0.01172f
C49 XOR_2_2/A XOR_2_2/li_n59_n770# 0.01038f
C50 XOR_2_2/A XOR_2_2/m1_n59_n770# 0.14583f
C51 XOR_2_2/A S2 0.02595f
C52 XOR_2_2/A VDD 1.9511f
C53 XOR_2_2/A AND_2_1/a_242_n201# 0.0253f
C54 XOR_2_2/A AND_2_1/a_329_n201# 0
C55 XOR_2_2/A OR_2_4/A 0.92469f
C56 XOR_2_2/A XOR_3_2/li_n59_n770# 0
C57 XOR_2_2/A OR_2_4/B 0
C58 XOR_2_2/A OR_1_4/Y 0.03395f
C59 AND_1_1/a_242_n201# OR_1_4/A 0.00134f
C60 AND_1_1/a_242_n201# VDD 0
C61 AND_1_1/a_242_n201# XOR_1_2/A 0.0253f
C62 AND_1_1/a_329_n201# XOR_1_2/A 0
C63 OR_1_4/A AND_1_3/a_242_n201# 0.01527f
C64 OR_1_4/A OR_1_4/B 0.03476f
C65 OR_1_4/A VDD 1.36164f
C66 OR_1_4/A OR_0_4/Y 0.30947f
C67 OR_1_4/A A1 0
C68 OR_1_4/A B1 0
C69 OR_1_4/A XOR_1_2/A 0.92469f
C70 OR_1_4/A XOR_1_2/a_744_n285# 0.04151f
C71 OR_1_4/A XOR_1_2/a_831_164# 0.00288f
C72 OR_1_4/A XOR_1_2/a_1028_164# 0.02933f
C73 OR_1_4/A XOR_1_2/a_1115_n285# 0.0013f
C74 OR_1_4/A XOR_1_2/li_n59_n770# 0.0119f
C75 OR_1_4/A XOR_1_2/m1_n59_n770# 0.14012f
C76 OR_1_4/A S1 0.57215f
C77 OR_1_4/A OR_1_4/Y 0.11645f
C78 XOR_2_2/a_744_n285# S2 0
C79 XOR_2_2/a_744_n285# VDD 0
C80 XOR_2_2/a_744_n285# OR_2_4/A 0.04151f
C81 XOR_2_2/a_744_n285# OR_1_4/Y 0.01572f
C82 XOR_2_2/a_831_164# OR_2_4/A 0.00288f
C83 XOR_2_2/a_1028_164# OR_2_4/A 0.02933f
C84 XOR_2_2/a_1028_164# OR_1_4/Y 0.00101f
C85 XOR_2_2/a_1115_n285# OR_2_4/A 0.0013f
C86 XOR_2_2/a_1115_n285# OR_1_4/Y 0.00169f
C87 XOR_2_2/li_n59_n770# VDD 0.01127f
C88 XOR_2_2/li_n59_n770# OR_2_4/Y 0
C89 XOR_2_2/li_n59_n770# OR_2_4/A 0.0119f
C90 XOR_2_2/li_n59_n770# XOR_3_2/li_n59_n770# 0.00538f
C91 XOR_2_2/li_n59_n770# XOR_1_2/A 0
C92 XOR_2_2/li_n59_n770# XOR_1_2/li_n59_n770# 0.00539f
C93 XOR_2_2/li_n59_n770# OR_1_4/Y 0.01008f
C94 XOR_2_2/m1_n59_n770# VDD 0.03311f
C95 XOR_2_2/m1_n59_n770# OR_2_4/A 0.14012f
C96 XOR_2_2/m1_n59_n770# XOR_3_2/m1_n59_n770# 0.00913f
C97 XOR_2_2/m1_n59_n770# XOR_1_2/m1_n59_n770# 0.00914f
C98 XOR_2_2/m1_n59_n770# OR_1_4/Y 0.15122f
C99 S2 VDD 0.21235f
C100 S2 OR_2_4/a_407_n201# 0.02082f
C101 S2 OR_2_4/Y 1.01574f
C102 S2 OR_2_4/A 0.57215f
C103 S2 AND_2_3/a_242_n201# 0.04856f
C104 S2 AND_2_3/a_329_n201# 0.00202f
C105 S2 OR_2_4/B 0.44385f
C106 S2 OR_1_4/Y 0.3665f
C107 AND_1_3/a_242_n201# OR_1_4/B 0.00124f
C108 AND_1_3/a_242_n201# VDD 0
C109 AND_1_3/a_242_n201# OR_0_4/Y 0.00563f
C110 AND_1_3/a_242_n201# S1 0.04856f
C111 AND_1_3/a_242_n201# OR_1_4/Y 0.0012f
C112 AND_1_3/a_329_n201# OR_1_4/B 0
C113 AND_1_3/a_329_n201# OR_0_4/Y 0.00149f
C114 AND_1_3/a_329_n201# S1 0.00202f
C115 OR_1_4/B VDD 0.00849f
C116 OR_1_4/B OR_0_4/Y 0.18848f
C117 OR_1_4/B XOR_1_2/A 0
C118 OR_1_4/B S1 0.44385f
C119 OR_1_4/B OR_1_4/a_407_n201# 0.00144f
C120 OR_1_4/B OR_1_4/Y 0.05087f
C121 XOR_0_0/a_744_n285# XOR_0_0/m1_n59_n770# 0
C122 XOR_0_0/a_744_n285# VDD 0
C123 XOR_0_0/a_744_n285# A0 0.01551f
C124 XOR_0_0/a_744_n285# B0 0.00761f
C125 XOR_0_0/a_744_n285# XOR_0_2/A 0
C126 XOR_0_0/a_744_n285# Cin 0.04306f
C127 XOR_0_0/a_831_164# A0 0.00272f
C128 XOR_0_0/a_831_164# Cin 0.00183f
C129 XOR_0_0/a_1028_164# A0 0.01486f
C130 XOR_0_0/a_1028_164# Cin 0.00925f
C131 XOR_0_0/a_1115_n285# B0 0.00151f
C132 XOR_0_0/a_1115_n285# Cin 0.00209f
C133 XOR_0_0/li_n59_n770# VDD 0.01183f
C134 XOR_0_0/li_n59_n770# A0 0.01032f
C135 XOR_0_0/li_n59_n770# B0 0.01032f
C136 XOR_0_0/li_n59_n770# Cin 0.01077f
C137 XOR_0_0/li_n59_n770# XOR_1_0/li_n59_n770# 0.00539f
C138 XOR_0_0/li_n59_n770# B1 0
C139 XOR_0_0/m1_n59_n770# VDD 0.038f
C140 XOR_0_0/m1_n59_n770# A0 0.15131f
C141 XOR_0_0/m1_n59_n770# B0 0.14595f
C142 XOR_0_0/m1_n59_n770# Cin 0.13804f
C143 XOR_0_0/m1_n59_n770# XOR_1_0/m1_n59_n770# 0.00914f
C144 VDD A0 1.09724f
C145 VDD B0 0.01142f
C146 VDD XOR_0_2/A 1.95085f
C147 VDD XOR_0_2/a_744_n285# 0
C148 VDD XOR_0_2/li_n59_n770# 0.00985f
C149 VDD XOR_0_2/m1_n59_n770# 0.03217f
C150 VDD Cin 0.14155f
C151 VDD S0 0.21207f
C152 VDD OR_2_4/a_407_n201# 0.00206f
C153 VDD OR_2_4/a_494_80# 0
C154 VDD OR_2_4/Y 0.62679f
C155 VDD OR_0_4/a_407_n201# 0.002f
C156 VDD OR_0_4/a_494_80# 0
C157 VDD OR_0_4/Y 0.62628f
C158 VDD AND_2_1/a_242_n201# 0
C159 VDD OR_2_4/A 1.36219f
C160 VDD XOR_3_0/a_744_n285# 0
C161 VDD XOR_3_0/li_n59_n770# 0.01323f
C162 VDD XOR_3_0/m1_n59_n770# 0.03901f
C163 VDD A3 1.09727f
C164 VDD B3 0.05773f
C165 VDD XOR_3_2/A 1.95118f
C166 VDD XOR_3_2/a_744_n285# 0
C167 VDD XOR_3_2/li_n59_n770# 0.01125f
C168 VDD XOR_3_2/m1_n59_n770# 0.03308f
C169 VDD S3 0.36941f
C170 VDD AND_2_3/a_242_n201# 0
C171 VDD OR_2_4/B 0.00849f
C172 VDD AND_0_1/a_242_n201# 0
C173 VDD OR_0_4/A 1.3619f
C174 VDD XOR_1_0/a_744_n285# 0
C175 VDD XOR_1_0/li_n59_n770# 0.01325f
C176 VDD XOR_1_0/m1_n59_n770# 0.03904f
C177 VDD A1 1.09706f
C178 VDD B1 0.05773f
C179 VDD XOR_1_2/A 1.95042f
C180 VDD AND_0_3/a_242_n201# 0
C181 VDD OR_0_4/B 0.00539f
C182 VDD XOR_1_2/a_744_n285# 0
C183 VDD XOR_1_2/li_n59_n770# 0.01127f
C184 VDD XOR_1_2/m1_n59_n770# 0.03312f
C185 VDD S1 0.21231f
C186 VDD OR_3_4/a_407_n201# 0.00335f
C187 VDD OR_3_4/a_494_80# 0
C188 VDD Cout 0.0819f
C189 VDD OR_1_4/a_407_n201# 0.00206f
C190 VDD OR_1_4/a_494_80# 0
C191 VDD OR_1_4/Y 0.62653f
C192 VDD AND_3_1/a_242_n201# 0
C193 VDD OR_3_4/A 1.36237f
C194 A0 B0 0.02697f
C195 A0 XOR_0_2/A 0.20323f
C196 A0 Cin 0.34884f
C197 A0 OR_0_4/A 0
C198 A0 XOR_1_0/li_n59_n770# 0
C199 B0 XOR_0_2/A 0.02146f
C200 B0 Cin 0.89401f
C201 B0 OR_0_4/A 0
C202 XOR_0_2/A XOR_0_2/a_744_n285# 0.0083f
C203 XOR_0_2/A XOR_0_2/a_831_164# 0.00264f
C204 XOR_0_2/A XOR_0_2/a_1028_164# 0.01172f
C205 XOR_0_2/A XOR_0_2/li_n59_n770# 0.01039f
C206 XOR_0_2/A XOR_0_2/m1_n59_n770# 0.14586f
C207 XOR_0_2/A Cin 0.54572f
C208 XOR_0_2/A S0 0.02595f
C209 XOR_0_2/A AND_0_1/a_242_n201# 0.0253f
C210 XOR_0_2/A AND_0_1/a_329_n201# 0
C211 XOR_0_2/A OR_0_4/A 0.92469f
C212 XOR_0_2/A OR_0_4/B 0
C213 XOR_0_2/A XOR_1_2/li_n59_n770# 0
C214 XOR_0_2/a_744_n285# Cin 0.01572f
C215 XOR_0_2/a_744_n285# S0 0
C216 XOR_0_2/a_744_n285# OR_0_4/A 0.04151f
C217 XOR_0_2/a_831_164# OR_0_4/A 0.00288f
C218 XOR_0_2/a_1028_164# Cin 0.00101f
C219 XOR_0_2/a_1028_164# OR_0_4/A 0.02933f
C220 XOR_0_2/a_1115_n285# Cin 0.00169f
C221 XOR_0_2/a_1115_n285# OR_0_4/A 0.0013f
C222 XOR_0_2/li_n59_n770# Cin 0.01039f
C223 XOR_0_2/li_n59_n770# OR_0_4/Y 0
C224 XOR_0_2/li_n59_n770# OR_0_4/A 0.0119f
C225 XOR_0_2/li_n59_n770# XOR_1_2/li_n59_n770# 0.00539f
C226 XOR_0_2/m1_n59_n770# Cin 0.15122f
C227 XOR_0_2/m1_n59_n770# OR_0_4/A 0.14012f
C228 XOR_0_2/m1_n59_n770# XOR_1_2/m1_n59_n770# 0.00914f
C229 Cin S0 0.09885f
C230 Cin OR_0_4/Y 0
C231 Cin AND_0_1/a_242_n201# 0.01415f
C232 Cin AND_0_1/a_329_n201# 0.0024f
C233 Cin OR_0_4/A 0.37566f
C234 Cin OR_0_4/B 0.00103f
C235 S0 OR_0_4/a_407_n201# 0.02082f
C236 S0 OR_0_4/Y 1.01574f
C237 S0 OR_0_4/A 0.57215f
C238 S0 AND_0_3/a_242_n201# 0.04856f
C239 S0 AND_0_3/a_329_n201# 0.00202f
C240 S0 OR_0_4/B 0.36059f
C241 OR_2_4/a_407_n201# OR_2_4/Y 0.04205f
C242 OR_2_4/a_407_n201# OR_2_4/B 0.00144f
C243 OR_2_4/a_494_80# OR_2_4/Y 0.00319f
C244 OR_2_4/Y OR_2_4/A 0.11645f
C245 OR_2_4/Y XOR_3_2/A 0.03395f
C246 OR_2_4/Y XOR_3_2/a_744_n285# 0.01572f
C247 OR_2_4/Y XOR_3_2/a_1028_164# 0.00101f
C248 OR_2_4/Y XOR_3_2/a_1115_n285# 0.00169f
C249 OR_2_4/Y XOR_3_2/li_n59_n770# 0.01008f
C250 OR_2_4/Y XOR_3_2/m1_n59_n770# 0.15122f
C251 OR_2_4/Y S3 0.43047f
C252 OR_2_4/Y AND_2_3/a_242_n201# 0.0012f
C253 OR_2_4/Y OR_2_4/B 0.05087f
C254 OR_2_4/Y OR_1_4/Y 0.01373f
C255 OR_2_4/Y OR_3_4/A 0.30965f
C256 OR_0_4/a_407_n201# OR_0_4/Y 0.04205f
C257 OR_0_4/a_407_n201# OR_0_4/B 0.00144f
C258 OR_0_4/a_494_80# OR_0_4/Y 0.00319f
C259 OR_0_4/Y OR_0_4/A 0.11645f
C260 OR_0_4/Y XOR_1_2/A 0.03395f
C261 OR_0_4/Y AND_0_3/a_242_n201# 0.0012f
C262 OR_0_4/Y OR_0_4/B 0.04996f
C263 OR_0_4/Y XOR_1_2/a_744_n285# 0.01572f
C264 OR_0_4/Y XOR_1_2/a_1028_164# 0.00101f
C265 OR_0_4/Y XOR_1_2/a_1115_n285# 0.00169f
C266 OR_0_4/Y XOR_1_2/li_n59_n770# 0.01008f
C267 OR_0_4/Y XOR_1_2/m1_n59_n770# 0.15122f
C268 OR_0_4/Y S1 0.3665f
C269 OR_0_4/Y OR_1_4/Y 0.01373f
C270 AND_2_1/a_242_n201# OR_2_4/A 0.00134f
C271 OR_2_4/A AND_2_3/a_242_n201# 0.01527f
C272 OR_2_4/A OR_2_4/B 0.03476f
C273 OR_2_4/A OR_1_4/Y 0.30947f
C274 XOR_3_0/a_744_n285# XOR_3_0/m1_n59_n770# 0
C275 XOR_3_0/a_744_n285# A3 0.01788f
C276 XOR_3_0/a_744_n285# B3 0.0177f
C277 XOR_3_0/a_744_n285# XOR_3_2/A 0
C278 XOR_3_0/a_831_164# A3 0.00272f
C279 XOR_3_0/a_831_164# B3 0.00104f
C280 XOR_3_0/a_1028_164# A3 0.01486f
C281 XOR_3_0/a_1028_164# B3 0.0041f
C282 XOR_3_0/a_1115_n285# A3 0
C283 XOR_3_0/a_1115_n285# B3 0.00169f
C284 XOR_3_0/li_n59_n770# A3 0.01032f
C285 XOR_3_0/li_n59_n770# B3 0.01032f
C286 XOR_3_0/m1_n59_n770# A3 0.15292f
C287 XOR_3_0/m1_n59_n770# B3 0.15292f
C288 A3 B3 0.24926f
C289 A3 XOR_3_2/A 0.20552f
C290 A3 OR_3_4/A 0
C291 B3 XOR_3_2/A 0.11319f
C292 B3 OR_3_4/A 0
C293 XOR_3_2/A XOR_3_2/a_744_n285# 0.0083f
C294 XOR_3_2/A XOR_3_2/a_831_164# 0.00264f
C295 XOR_3_2/A XOR_3_2/a_1028_164# 0.01172f
C296 XOR_3_2/A XOR_3_2/li_n59_n770# 0.01039f
C297 XOR_3_2/A XOR_3_2/m1_n59_n770# 0.14586f
C298 XOR_3_2/A S3 0.02595f
C299 XOR_3_2/A AND_3_1/a_242_n201# 0.0253f
C300 XOR_3_2/A AND_3_1/a_329_n201# 0
C301 XOR_3_2/A OR_3_4/A 0.92469f
C302 XOR_3_2/a_744_n285# S3 0
C303 XOR_3_2/a_744_n285# OR_3_4/A 0.04151f
C304 XOR_3_2/a_831_164# OR_3_4/A 0.00288f
C305 XOR_3_2/a_1028_164# OR_3_4/A 0.02933f
C306 XOR_3_2/a_1115_n285# OR_3_4/A 0.0013f
C307 XOR_3_2/li_n59_n770# OR_3_4/A 0.0119f
C308 XOR_3_2/m1_n59_n770# OR_3_4/A 0.14012f
C309 S3 OR_3_4/a_407_n201# 0.0342f
C310 S3 OR_3_4/a_494_80# 0.00215f
C311 S3 Cout 0.43543f
C312 S3 OR_3_4/A 0.56072f
C313 AND_2_3/a_242_n201# OR_2_4/B 0.00124f
C314 AND_2_3/a_242_n201# OR_1_4/Y 0.00563f
C315 AND_2_3/a_329_n201# OR_2_4/B 0
C316 AND_2_3/a_329_n201# OR_1_4/Y 0.00149f
C317 OR_2_4/B OR_1_4/Y 0.18848f
C318 AND_0_1/a_242_n201# OR_0_4/A 0.00134f
C319 OR_0_4/A AND_0_3/a_242_n201# 0.01527f
C320 OR_0_4/A OR_0_4/B 0.03461f
C321 XOR_1_0/a_744_n285# XOR_1_0/m1_n59_n770# 0
C322 XOR_1_0/a_744_n285# A1 0.01788f
C323 XOR_1_0/a_744_n285# B1 0.0177f
C324 XOR_1_0/a_744_n285# XOR_1_2/A 0
C325 XOR_1_0/a_831_164# A1 0.00272f
C326 XOR_1_0/a_831_164# B1 0.00104f
C327 XOR_1_0/a_1028_164# A1 0.01486f
C328 XOR_1_0/a_1028_164# B1 0.0041f
C329 XOR_1_0/a_1115_n285# A1 0
C330 XOR_1_0/a_1115_n285# B1 0.00169f
C331 XOR_1_0/li_n59_n770# A1 0.01031f
C332 XOR_1_0/li_n59_n770# B1 0.01032f
C333 XOR_1_0/m1_n59_n770# A1 0.1529f
C334 XOR_1_0/m1_n59_n770# B1 0.15292f
C335 A1 B1 0.24926f
C336 A1 XOR_1_2/A 0.20552f
C337 B1 XOR_1_2/A 0.11319f
C338 XOR_1_2/A XOR_1_2/a_744_n285# 0.0083f
C339 XOR_1_2/A XOR_1_2/a_831_164# 0.00264f
C340 XOR_1_2/A XOR_1_2/a_1028_164# 0.01172f
C341 XOR_1_2/A XOR_1_2/li_n59_n770# 0.01039f
C342 XOR_1_2/A XOR_1_2/m1_n59_n770# 0.14584f
C343 XOR_1_2/A S1 0.02595f
C344 AND_0_3/a_242_n201# OR_0_4/B 0.00124f
C345 AND_0_3/a_329_n201# OR_0_4/B 0
C346 XOR_1_2/a_744_n285# S1 0
C347 XOR_1_2/li_n59_n770# OR_1_4/Y 0
C348 S1 OR_1_4/a_407_n201# 0.02082f
C349 S1 OR_1_4/Y 1.01574f
C350 OR_3_4/a_407_n201# Cout 0
C351 Cout OR_3_4/A 0
C352 OR_1_4/a_407_n201# OR_1_4/Y 0.04205f
C353 OR_1_4/a_494_80# OR_1_4/Y 0.00319f
C354 AND_3_1/a_242_n201# OR_3_4/A 0.00134f
C355 OR_3_4/A VSS 0.85631f
C356 AND_3_1/a_329_n201# VSS 0
C357 AND_3_1/a_242_n201# VSS 0.00358f
C358 OR_1_4/Y VSS 3.92388f
C359 OR_1_4/a_407_n201# VSS 0
C360 Cout VSS 0.51471f
C361 OR_3_4/a_407_n201# VSS 0
C362 S1 VSS 0.97713f
C363 XOR_1_2/m1_n59_n770# VSS 0.03312f
C364 XOR_1_2/li_n59_n770# VSS 0.01128f
C365 XOR_1_2/a_744_n285# VSS 0
C366 OR_0_4/B VSS 0.56702f
C367 AND_0_3/a_329_n201# VSS 0
C368 AND_0_3/a_242_n201# VSS 0.0014f
C369 XOR_1_2/A VSS 1.31246f
C370 B1 VSS 1.80407f
C371 A1 VSS 0.74462f
C372 XOR_1_0/m1_n59_n770# VSS 0.03312f
C373 XOR_1_0/li_n59_n770# VSS 0.01128f
C374 XOR_1_0/a_744_n285# VSS 0
C375 OR_0_4/A VSS 0.80939f
C376 AND_0_1/a_242_n201# VSS 0
C377 OR_2_4/B VSS 0.47127f
C378 AND_2_3/a_242_n201# VSS 0
C379 S3 VSS 0.98073f
C380 XOR_3_2/m1_n59_n770# VSS 0.03217f
C381 XOR_3_2/li_n59_n770# VSS 0.00985f
C382 XOR_3_2/a_744_n285# VSS 0
C383 XOR_3_2/A VSS 1.30632f
C384 B3 VSS 1.80393f
C385 A3 VSS 0.73831f
C386 XOR_3_0/m1_n59_n770# VSS 0.03217f
C387 XOR_3_0/li_n59_n770# VSS 0.00985f
C388 XOR_3_0/a_744_n285# VSS 0
C389 OR_2_4/A VSS 0.86226f
C390 AND_2_1/a_329_n201# VSS 0
C391 AND_2_1/a_242_n201# VSS 0.00365f
C392 OR_0_4/Y VSS 4.16158f
C393 OR_0_4/a_407_n201# VSS 0
C394 OR_2_4/Y VSS 3.88248f
C395 OR_2_4/a_407_n201# VSS 0
C396 S0 VSS 1.16482f
C397 Cin VSS 4.06409f
C398 XOR_0_2/m1_n59_n770# VSS 0.03313f
C399 XOR_0_2/li_n59_n770# VSS 0.01129f
C400 XOR_0_2/a_744_n285# VSS 0
C401 XOR_0_2/A VSS 1.13526f
C402 B0 VSS 1.61268f
C403 A0 VSS 0.66317f
C404 VDD VSS 32.7417f
C405 XOR_0_0/m1_n59_n770# VSS 0.03313f
C406 XOR_0_0/li_n59_n770# VSS 0.01129f
C407 XOR_0_0/a_744_n285# VSS 0
C408 OR_1_4/B VSS 0.47127f
C409 AND_1_3/a_242_n201# VSS 0
C410 S2 VSS 0.97713f
C411 XOR_2_2/m1_n59_n770# VSS 0.03312f
C412 XOR_2_2/li_n59_n770# VSS 0.01128f
C413 XOR_2_2/a_744_n285# VSS 0
C414 OR_1_4/A VSS 0.86226f
C415 AND_1_1/a_329_n201# VSS 0
C416 AND_1_1/a_242_n201# VSS 0.00365f
C417 XOR_2_2/A VSS 1.31246f
C418 B2 VSS 1.80407f
C419 A2 VSS 0.74462f
C420 XOR_2_0/m1_n59_n770# VSS 0.03312f
C421 XOR_2_0/li_n59_n770# VSS 0.01128f
C422 XOR_2_0/a_744_n285# VSS 0
C423 OR_3_4/B VSS 0.49676f
C424 AND_3_3/a_242_n201# VSS 0
.ends

XDUT A0 A1 A2 A3 B0 B1 B2 B3 Cin S0 S1 S2 S3 Cout VDD VSS ADD4
VDD VDD 0 1.8
VSS VSS 0 0
VA0 A0 0 PWL(0 0 1.5e-09 0 1.55e-09 1.8 3e-09 1.8 3.05e-09 1.8 4.5e-09 1.8 4.55e-09 0 6e-09 0 6.05e-09 0 7.5e-09 0 7.55e-09 1.8 9e-09 1.8 9.05e-09 1.8 1.05e-08 1.8 1.055e-08 0 1.2e-08 0 1.205e-08 0 1.35e-08 0 1.355e-08 1.8 1.5e-08 1.8 1.505e-08 1.8 1.65e-08 1.8 1.655e-08 0 1.8e-08 0 1.805e-08 0 1.95e-08 0 1.955e-08 1.8 2.1e-08 1.8 2.105e-08 1.8 2.25e-08 1.8 2.255e-08 0 2.4e-08 0 2.405e-08 0 2.55e-08 0 2.555e-08 1.8 2.7e-08 1.8 2.705e-08 1.8 2.85e-08 1.8 2.855e-08 0 3e-08 0 3.005e-08 0 3.15e-08 0 3.155e-08 1.8 3.3e-08 1.8 3.305e-08 1.8 3.45e-08 1.8 3.455e-08 0 3.6e-08 0 3.605e-08 0 3.75e-08 0 3.755e-08 1.8 3.9e-08 1.8 3.905e-08 1.8 4.05e-08 1.8 4.055e-08 0 4.2e-08 0 4.205e-08 0 4.35e-08 0 4.355e-08 1.8 4.5e-08 1.8 4.505e-08 1.8 4.65e-08 1.8 4.655e-08 0 4.8e-08 0 4.805e-08 0 4.95e-08 0 4.955e-08 1.8 5.1e-08 1.8 5.105e-08 1.8 5.25e-08 1.8 5.255e-08 0 5.4e-08 0 5.405e-08 0 5.55e-08 0 5.555e-08 1.8 5.7e-08 1.8 5.705e-08 1.8 5.85e-08 1.8 5.855e-08 0 6e-08 0 6.005e-08 0 6.15e-08 0 6.155e-08 1.8 6.3e-08 1.8 6.305e-08 1.8 6.45e-08 1.8 6.455e-08 0 6.6e-08 0 6.605e-08 0 6.75e-08 0 6.755e-08 1.8 6.9e-08 1.8 6.905e-08 1.8 7.05e-08 1.8 7.055e-08 0 7.2e-08 0 7.205e-08 0 7.35e-08 0 7.355e-08 1.8 7.5e-08 1.8 7.505e-08 1.8 7.65e-08 1.8 7.655e-08 0 7.8e-08 0 7.805e-08 0 7.95e-08 0 7.955e-08 1.8 8.1e-08 1.8 8.105e-08 1.8 8.25e-08 1.8 8.255e-08 0 8.4e-08 0 8.405e-08 0 8.55e-08 0 8.555e-08 1.8 8.7e-08 1.8 8.705e-08 1.8 8.85e-08 1.8 8.855e-08 0 9e-08 0 9.005e-08 0 9.15e-08 0 9.155e-08 1.8 9.3e-08 1.8 9.305e-08 1.8 9.45e-08 1.8 9.455e-08 0 9.6e-08 0 9.605e-08 0 9.75e-08 0 9.755e-08 1.8 9.9e-08 1.8 9.905e-08 1.8 1.005e-07 1.8 1.005e-07 0 1.02e-07 0 1.021e-07 0 1.035e-07 0 1.035e-07 1.8 1.05e-07 1.8 1.051e-07 1.8 1.065e-07 1.8 1.065e-07 0 1.08e-07 0 1.081e-07 0 1.095e-07 0 1.095e-07 1.8 1.11e-07 1.8 1.111e-07 1.8 1.125e-07 1.8 1.125e-07 0 1.14e-07 0 1.141e-07 0 1.155e-07 0 1.155e-07 1.8 1.17e-07 1.8 1.171e-07 1.8 1.185e-07 1.8 1.185e-07 0 1.2e-07 0 1.2e-07 0 1.215e-07 0 1.215e-07 1.8 1.23e-07 1.8 1.231e-07 1.8 1.245e-07 1.8 1.246e-07 0 1.26e-07 0 1.26e-07 0 1.275e-07 0 1.276e-07 1.8 1.29e-07 1.8 1.291e-07 1.8 1.305e-07 1.8 1.306e-07 0 1.32e-07 0 1.32e-07 0 1.335e-07 0 1.336e-07 1.8 1.35e-07 1.8 1.351e-07 1.8 1.365e-07 1.8 1.366e-07 0 1.38e-07 0 1.38e-07 0 1.395e-07 0 1.396e-07 1.8 1.41e-07 1.8 1.411e-07 1.8 1.425e-07 1.8 1.426e-07 0 1.44e-07 0 1.44e-07 0 1.455e-07 0 1.456e-07 1.8 1.47e-07 1.8 1.471e-07 1.8 1.485e-07 1.8 1.485e-07 0 1.5e-07 0 1.5e-07 0 1.515e-07 0 1.516e-07 1.8 1.53e-07 1.8 1.531e-07 1.8 1.545e-07 1.8 1.545e-07 0 1.56e-07 0 1.56e-07 0 1.575e-07 0 1.576e-07 1.8 1.59e-07 1.8 1.591e-07 1.8 1.605e-07 1.8 1.605e-07 0 1.62e-07 0 1.62e-07 0 1.635e-07 0 1.636e-07 1.8 1.65e-07 1.8 1.651e-07 1.8 1.665e-07 1.8 1.665e-07 0 1.68e-07 0 1.68e-07 0 1.695e-07 0 1.696e-07 1.8 1.71e-07 1.8 1.711e-07 1.8 1.725e-07 1.8 1.725e-07 0 1.74e-07 0 1.741e-07 0 1.755e-07 0 1.756e-07 1.8 1.77e-07 1.8 1.771e-07 1.8 1.785e-07 1.8 1.785e-07 0 1.8e-07 0 1.801e-07 0 1.815e-07 0 1.816e-07 1.8 1.83e-07 1.8 1.831e-07 1.8 1.845e-07 1.8 1.845e-07 0 1.86e-07 0 1.861e-07 0 1.875e-07 0 1.876e-07 1.8 1.89e-07 1.8 1.891e-07 1.8 1.905e-07 1.8 1.905e-07 0 1.92e-07 0 1.921e-07 0 1.935e-07 0 1.936e-07 1.8 1.95e-07 1.8 1.95e-07 1.8 1.965e-07 1.8 1.965e-07 0 1.98e-07 0 1.981e-07 0 1.995e-07 0 1.996e-07 1.8 2.01e-07 1.8 2.01e-07 1.8 2.025e-07 1.8 2.025e-07 0 2.04e-07 0 2.041e-07 0 2.055e-07 0 2.056e-07 1.8 2.07e-07 1.8 2.07e-07 1.8 2.085e-07 1.8 2.085e-07 0 2.1e-07 0 2.101e-07 0 2.115e-07 0 2.116e-07 1.8 2.13e-07 1.8 2.13e-07 1.8 2.145e-07 1.8 2.145e-07 0 2.16e-07 0 2.161e-07 0 2.175e-07 0 2.176e-07 1.8 2.19e-07 1.8 2.19e-07 1.8 2.205e-07 1.8 2.205e-07 0 2.22e-07 0 2.221e-07 0 2.235e-07 0 2.236e-07 1.8 2.25e-07 1.8 2.25e-07 1.8 2.265e-07 1.8 2.266e-07 0 2.28e-07 0 2.281e-07 0 2.295e-07 0 2.296e-07 1.8 2.31e-07 1.8 2.31e-07 1.8 2.325e-07 1.8 2.326e-07 0 2.34e-07 0 2.341e-07 0 2.355e-07 0 2.356e-07 1.8 2.37e-07 1.8 2.37e-07 1.8 2.385e-07 1.8 2.386e-07 0 2.4e-07 0 2.4e-07 0 2.415e-07 0 2.415e-07 1.8 2.43e-07 1.8 2.43e-07 1.8 2.445e-07 1.8 2.446e-07 0 2.46e-07 0 2.461e-07 0 2.475e-07 0 2.476e-07 1.8 2.49e-07 1.8 2.491e-07 1.8 2.505e-07 1.8 2.505e-07 0 2.52e-07 0 2.52e-07 0 2.535e-07 0 2.535e-07 1.8 2.55e-07 1.8 2.55e-07 1.8 2.565e-07 1.8 2.566e-07 0 2.58e-07 0 2.581e-07 0 2.595e-07 0 2.596e-07 1.8 2.61e-07 1.8 2.611e-07 1.8 2.625e-07 1.8 2.625e-07 0 2.64e-07 0 2.64e-07 0 2.655e-07 0 2.655e-07 1.8 2.67e-07 1.8 2.67e-07 1.8 2.685e-07 1.8 2.686e-07 0 2.7e-07 0 2.701e-07 0 2.715e-07 0 2.716e-07 1.8 2.73e-07 1.8 2.731e-07 1.8 2.745e-07 1.8 2.745e-07 0 2.76e-07 0 2.76e-07 0 2.775e-07 0 2.775e-07 1.8 2.79e-07 1.8 2.791e-07 1.8 2.805e-07 1.8 2.806e-07 0 2.82e-07 0 2.821e-07 0 2.835e-07 0 2.836e-07 1.8 2.85e-07 1.8 2.851e-07 1.8 2.865e-07 1.8 2.865e-07 0 2.88e-07 0 2.88e-07 0 2.895e-07 0 2.895e-07 1.8 2.91e-07 1.8 2.911e-07 1.8 2.925e-07 1.8 2.926e-07 0 2.94e-07 0 2.941e-07 0 2.955e-07 0 2.956e-07 1.8 2.97e-07 1.8 2.97e-07 1.8 2.985e-07 1.8 2.985e-07 0 3e-07 0 3e-07 0 3.015e-07 0 3.015e-07 1.8 3.03e-07 1.8 3.031e-07 1.8 3.045e-07 1.8 3.046e-07 0 3.06e-07 0 3.061e-07 0 3.075e-07 0 3.076e-07 1.8 3.09e-07 1.8 3.09e-07 1.8 3.105e-07 1.8 3.105e-07 0 3.12e-07 0 3.12e-07 0 3.135e-07 0 3.135e-07 1.8 3.15e-07 1.8 3.151e-07 1.8 3.165e-07 1.8 3.166e-07 0 3.18e-07 0 3.181e-07 0 3.195e-07 0 3.196e-07 1.8 3.21e-07 1.8 3.21e-07 1.8 3.225e-07 1.8 3.225e-07 0 3.24e-07 0 3.24e-07 0 3.255e-07 0 3.256e-07 1.8 3.27e-07 1.8 3.271e-07 1.8 3.285e-07 1.8 3.286e-07 0 3.3e-07 0 3.301e-07 0 3.315e-07 0 3.316e-07 1.8 3.33e-07 1.8 3.33e-07 1.8 3.345e-07 1.8 3.345e-07 0 3.36e-07 0 3.36e-07 0 3.375e-07 0 3.376e-07 1.8 3.39e-07 1.8 3.391e-07 1.8 3.405e-07 1.8 3.406e-07 0 3.42e-07 0 3.421e-07 0 3.435e-07 0 3.435e-07 1.8 3.45e-07 1.8 3.45e-07 1.8 3.465e-07 1.8 3.465e-07 0 3.48e-07 0 3.48e-07 0 3.495e-07 0 3.496e-07 1.8 3.51e-07 1.8 3.511e-07 1.8 3.525e-07 1.8 3.526e-07 0 3.54e-07 0 3.541e-07 0 3.555e-07 0 3.555e-07 1.8 3.57e-07 1.8 3.57e-07 1.8 3.585e-07 1.8 3.585e-07 0 3.6e-07 0 3.6e-07 0 3.615e-07 0 3.616e-07 1.8 3.63e-07 1.8 3.631e-07 1.8 3.645e-07 1.8 3.646e-07 0 3.66e-07 0 3.661e-07 0 3.675e-07 0 3.675e-07 1.8 3.69e-07 1.8 3.69e-07 1.8 3.705e-07 1.8 3.705e-07 0 3.72e-07 0 3.72e-07 0 3.735e-07 0 3.736e-07 1.8 3.75e-07 1.8 3.751e-07 1.8 3.765e-07 1.8 3.766e-07 0 3.78e-07 0 3.781e-07 0 3.795e-07 0 3.795e-07 1.8 3.81e-07 1.8 3.81e-07 1.8 3.825e-07 1.8 3.825e-07 0 3.84e-07 0 3.841e-07 0 3.855e-07 0 3.856e-07 1.8 3.87e-07 1.8 3.871e-07 1.8 3.885e-07 1.8 3.886e-07 0 3.9e-07 0 3.9e-07 0 3.915e-07 0 3.915e-07 1.8 3.93e-07 1.8 3.93e-07 1.8 3.945e-07 1.8 3.945e-07 0 3.96e-07 0 3.961e-07 0 3.975e-07 0 3.976e-07 1.8 3.99e-07 1.8 3.991e-07 1.8 4.005e-07 1.8 4.006e-07 0 4.02e-07 0 4.02e-07 0 4.035e-07 0 4.035e-07 1.8 4.05e-07 1.8 4.05e-07 1.8 4.065e-07 1.8 4.065e-07 0 4.08e-07 0 4.081e-07 0 4.095e-07 0 4.096e-07 1.8 4.11e-07 1.8 4.111e-07 1.8 4.125e-07 1.8 4.126e-07 0 4.14e-07 0 4.14e-07 0 4.155e-07 0 4.155e-07 1.8 4.17e-07 1.8 4.17e-07 1.8 4.185e-07 1.8 4.185e-07 0 4.2e-07 0 4.201e-07 0 4.215e-07 0 4.216e-07 1.8 4.23e-07 1.8 4.231e-07 1.8 4.245e-07 1.8 4.246e-07 0 4.26e-07 0 4.26e-07 0 4.275e-07 0 4.275e-07 1.8 4.29e-07 1.8 4.29e-07 1.8 4.305e-07 1.8 4.306e-07 0 4.32e-07 0 4.321e-07 0 4.335e-07 0 4.336e-07 1.8 4.35e-07 1.8 4.351e-07 1.8 4.365e-07 1.8 4.365e-07 0 4.38e-07 0 4.38e-07 0 4.395e-07 0 4.395e-07 1.8 4.41e-07 1.8 4.41e-07 1.8 4.425e-07 1.8 4.426e-07 0 4.44e-07 0 4.441e-07 0 4.455e-07 0 4.456e-07 1.8 4.47e-07 1.8 4.471e-07 1.8 4.485e-07 1.8 4.485e-07 0 4.5e-07 0 4.5e-07 0 4.515e-07 0 4.515e-07 1.8 4.53e-07 1.8 4.53e-07 1.8 4.545e-07 1.8 4.546e-07 0 4.56e-07 0 4.561e-07 0 4.575e-07 0 4.576e-07 1.8 4.59e-07 1.8 4.591e-07 1.8 4.605e-07 1.8 4.605e-07 0 4.62e-07 0 4.62e-07 0 4.635e-07 0 4.635e-07 1.8 4.65e-07 1.8 4.65e-07 1.8 4.665e-07 1.8 4.666e-07 0 4.68e-07 0 4.681e-07 0 4.695e-07 0 4.696e-07 1.8 4.71e-07 1.8 4.711e-07 1.8 4.725e-07 1.8 4.725e-07 0 4.74e-07 0 4.74e-07 0 4.755e-07 0 4.755e-07 1.8 4.77e-07 1.8 4.771e-07 1.8 4.785e-07 1.8 4.785e-07 0 4.8e-07 0 4.8e-07 0 4.815e-07 0 4.815e-07 1.8 4.83e-07 1.8 4.83e-07 1.8 4.845e-07 1.8 4.845e-07 0 4.86e-07 0 4.86e-07 0 4.875e-07 0 4.875e-07 1.8 4.89e-07 1.8 4.891e-07 1.8 4.905e-07 1.8 4.906e-07 0 4.92e-07 0 4.921e-07 0 4.935e-07 0 4.936e-07 1.8 4.95e-07 1.8 4.951e-07 1.8 4.965e-07 1.8 4.966e-07 0 4.98e-07 0 4.981e-07 0 4.995e-07 0 4.996e-07 1.8 5.01e-07 1.8 5.01e-07 1.8 5.025e-07 1.8 5.025e-07 0 5.04e-07 0 5.04e-07 0 5.055e-07 0 5.055e-07 1.8 5.07e-07 1.8 5.07e-07 1.8 5.085e-07 1.8 5.085e-07 0 5.1e-07 0 5.1e-07 0 5.115e-07 0 5.115e-07 1.8 5.13e-07 1.8 5.131e-07 1.8 5.145e-07 1.8 5.146e-07 0 5.16e-07 0 5.161e-07 0 5.175e-07 0 5.176e-07 1.8 5.19e-07 1.8 5.191e-07 1.8 5.205e-07 1.8 5.206e-07 0 5.22e-07 0 5.221e-07 0 5.235e-07 0 5.236e-07 1.8 5.25e-07 1.8 5.25e-07 1.8 5.265e-07 1.8 5.265e-07 0 5.28e-07 0 5.28e-07 0 5.295e-07 0 5.295e-07 1.8 5.31e-07 1.8 5.31e-07 1.8 5.325e-07 1.8 5.325e-07 0 5.34e-07 0 5.34e-07 0 5.355e-07 0 5.356e-07 1.8 5.37e-07 1.8 5.371e-07 1.8 5.385e-07 1.8 5.386e-07 0 5.4e-07 0 5.401e-07 0 5.415e-07 0 5.416e-07 1.8 5.43e-07 1.8 5.431e-07 1.8 5.445e-07 1.8 5.446e-07 0 5.46e-07 0 5.461e-07 0 5.475e-07 0 5.475e-07 1.8 5.49e-07 1.8 5.49e-07 1.8 5.505e-07 1.8 5.505e-07 0 5.52e-07 0 5.52e-07 0 5.535e-07 0 5.535e-07 1.8 5.55e-07 1.8 5.55e-07 1.8 5.565e-07 1.8 5.565e-07 0 5.58e-07 0 5.58e-07 0 5.595e-07 0 5.596e-07 1.8 5.61e-07 1.8 5.611e-07 1.8 5.625e-07 1.8 5.626e-07 0 5.64e-07 0 5.641e-07 0 5.655e-07 0 5.656e-07 1.8 5.67e-07 1.8 5.671e-07 1.8 5.685e-07 1.8 5.686e-07 0 5.7e-07 0 5.701e-07 0 5.715e-07 0 5.715e-07 1.8 5.73e-07 1.8 5.73e-07 1.8 5.745e-07 1.8 5.745e-07 0 5.76e-07 0 5.76e-07 0 5.775e-07 0 5.775e-07 1.8 5.79e-07 1.8 5.79e-07 1.8 5.805e-07 1.8 5.805e-07 0 5.82e-07 0 5.821e-07 0 5.835e-07 0 5.836e-07 1.8 5.85e-07 1.8 5.851e-07 1.8 5.865e-07 1.8 5.866e-07 0 5.88e-07 0 5.881e-07 0 5.895e-07 0 5.896e-07 1.8 5.91e-07 1.8 5.911e-07 1.8 5.925e-07 1.8 5.926e-07 0 5.94e-07 0 5.94e-07 0 5.955e-07 0 5.955e-07 1.8 5.97e-07 1.8 5.97e-07 1.8 5.985e-07 1.8 5.985e-07 0 6e-07 0 6e-07 0 6.015e-07 0 6.015e-07 1.8 6.03e-07 1.8 6.03e-07 1.8 6.045e-07 1.8 6.045e-07 0 6.06e-07 0 6.061e-07 0 6.075e-07 0 6.076e-07 1.8 6.09e-07 1.8 6.091e-07 1.8 6.105e-07 1.8 6.106e-07 0 6.12e-07 0 6.121e-07 0 6.135e-07 0 6.136e-07 1.8 6.15e-07 1.8 6.151e-07 1.8 6.165e-07 1.8 6.166e-07 0 6.18e-07 0 6.18e-07 0 6.195e-07 0 6.195e-07 1.8 6.21e-07 1.8 6.21e-07 1.8 6.225e-07 1.8 6.225e-07 0 6.24e-07 0 6.24e-07 0 6.255e-07 0 6.255e-07 1.8 6.27e-07 1.8 6.27e-07 1.8 6.285e-07 1.8 6.286e-07 0 6.3e-07 0 6.301e-07 0 6.315e-07 0 6.316e-07 1.8 6.33e-07 1.8 6.331e-07 1.8 6.345e-07 1.8 6.346e-07 0 6.36e-07 0 6.361e-07 0 6.375e-07 0 6.376e-07 1.8 6.39e-07 1.8 6.391e-07 1.8 6.405e-07 1.8 6.405e-07 0 6.42e-07 0 6.42e-07 0 6.435e-07 0 6.435e-07 1.8 6.45e-07 1.8 6.45e-07 1.8 6.465e-07 1.8 6.465e-07 0 6.48e-07 0 6.48e-07 0 6.495e-07 0 6.495e-07 1.8 6.51e-07 1.8 6.51e-07 1.8 6.525e-07 1.8 6.526e-07 0 6.54e-07 0 6.541e-07 0 6.555e-07 0 6.556e-07 1.8 6.57e-07 1.8 6.571e-07 1.8 6.585e-07 1.8 6.586e-07 0 6.6e-07 0 6.601e-07 0 6.615e-07 0 6.616e-07 1.8 6.63e-07 1.8 6.631e-07 1.8 6.645e-07 1.8 6.645e-07 0 6.66e-07 0 6.66e-07 0 6.675e-07 0 6.675e-07 1.8 6.69e-07 1.8 6.69e-07 1.8 6.705e-07 1.8 6.705e-07 0 6.72e-07 0 6.72e-07 0 6.735e-07 0 6.735e-07 1.8 6.75e-07 1.8 6.75e-07 1.8 6.765e-07 1.8 6.766e-07 0 6.78e-07 0 6.781e-07 0 6.795e-07 0 6.796e-07 1.8 6.81e-07 1.8 6.811e-07 1.8 6.825e-07 1.8 6.826e-07 0 6.84e-07 0 6.841e-07 0 6.855e-07 0 6.856e-07 1.8 6.87e-07 1.8 6.87e-07 1.8 6.885e-07 1.8 6.885e-07 0 6.9e-07 0 6.9e-07 0 6.915e-07 0 6.915e-07 1.8 6.93e-07 1.8 6.93e-07 1.8 6.945e-07 1.8 6.945e-07 0 6.96e-07 0 6.96e-07 0 6.975e-07 0 6.975e-07 1.8 6.99e-07 1.8 6.991e-07 1.8 7.005e-07 1.8 7.006e-07 0 7.02e-07 0 7.021e-07 0 7.035e-07 0 7.036e-07 1.8 7.05e-07 1.8 7.051e-07 1.8 7.065e-07 1.8 7.066e-07 0 7.08e-07 0 7.081e-07 0 7.095e-07 0 7.096e-07 1.8 7.11e-07 1.8 7.11e-07 1.8 7.125e-07 1.8 7.125e-07 0 7.14e-07 0 7.14e-07 0 7.155e-07 0 7.155e-07 1.8 7.17e-07 1.8 7.17e-07 1.8 7.185e-07 1.8 7.185e-07 0 7.2e-07 0 7.2e-07 0 7.215e-07 0 7.215e-07 1.8 7.23e-07 1.8 7.231e-07 1.8 7.245e-07 1.8 7.246e-07 0 7.26e-07 0 7.261e-07 0 7.275e-07 0 7.276e-07 1.8 7.29e-07 1.8 7.291e-07 1.8 7.305e-07 1.8 7.306e-07 0 7.32e-07 0 7.321e-07 0 7.335e-07 0 7.335e-07 1.8 7.35e-07 1.8 7.35e-07 1.8 7.365e-07 1.8 7.365e-07 0 7.38e-07 0 7.38e-07 0 7.395e-07 0 7.395e-07 1.8 7.41e-07 1.8 7.41e-07 1.8 7.425e-07 1.8 7.425e-07 0 7.44e-07 0 7.44e-07 0 7.455e-07 0 7.456e-07 1.8 7.47e-07 1.8 7.471e-07 1.8 7.485e-07 1.8 7.486e-07 0 7.5e-07 0 7.501e-07 0 7.515e-07 0 7.516e-07 1.8 7.53e-07 1.8 7.531e-07 1.8 7.545e-07 1.8 7.546e-07 0 7.56e-07 0 7.561e-07 0 7.575e-07 0 7.575e-07 1.8 7.59e-07 1.8 7.59e-07 1.8 7.605e-07 1.8 7.605e-07 0 7.62e-07 0 7.62e-07 0 7.635e-07 0 7.635e-07 1.8 7.65e-07 1.8 7.65e-07 1.8 7.665e-07 1.8 7.665e-07 0)
VA1 A1 0 PWL(0 0 1.5e-09 0 1.55e-09 0 3e-09 0 3.05e-09 1.8 4.5e-09 1.8 4.55e-09 1.8 6e-09 1.8 6.05e-09 1.8 7.5e-09 1.8 7.55e-09 1.8 9e-09 1.8 9.05e-09 0 1.05e-08 0 1.055e-08 0 1.2e-08 0 1.205e-08 0 1.35e-08 0 1.355e-08 0 1.5e-08 0 1.505e-08 1.8 1.65e-08 1.8 1.655e-08 1.8 1.8e-08 1.8 1.805e-08 1.8 1.95e-08 1.8 1.955e-08 1.8 2.1e-08 1.8 2.105e-08 0 2.25e-08 0 2.255e-08 0 2.4e-08 0 2.405e-08 0 2.55e-08 0 2.555e-08 0 2.7e-08 0 2.705e-08 1.8 2.85e-08 1.8 2.855e-08 1.8 3e-08 1.8 3.005e-08 1.8 3.15e-08 1.8 3.155e-08 1.8 3.3e-08 1.8 3.305e-08 0 3.45e-08 0 3.455e-08 0 3.6e-08 0 3.605e-08 0 3.75e-08 0 3.755e-08 0 3.9e-08 0 3.905e-08 1.8 4.05e-08 1.8 4.055e-08 1.8 4.2e-08 1.8 4.205e-08 1.8 4.35e-08 1.8 4.355e-08 1.8 4.5e-08 1.8 4.505e-08 0 4.65e-08 0 4.655e-08 0 4.8e-08 0 4.805e-08 0 4.95e-08 0 4.955e-08 0 5.1e-08 0 5.105e-08 1.8 5.25e-08 1.8 5.255e-08 1.8 5.4e-08 1.8 5.405e-08 1.8 5.55e-08 1.8 5.555e-08 1.8 5.7e-08 1.8 5.705e-08 0 5.85e-08 0 5.855e-08 0 6e-08 0 6.005e-08 0 6.15e-08 0 6.155e-08 0 6.3e-08 0 6.305e-08 1.8 6.45e-08 1.8 6.455e-08 1.8 6.6e-08 1.8 6.605e-08 1.8 6.75e-08 1.8 6.755e-08 1.8 6.9e-08 1.8 6.905e-08 0 7.05e-08 0 7.055e-08 0 7.2e-08 0 7.205e-08 0 7.35e-08 0 7.355e-08 0 7.5e-08 0 7.505e-08 1.8 7.65e-08 1.8 7.655e-08 1.8 7.8e-08 1.8 7.805e-08 1.8 7.95e-08 1.8 7.955e-08 1.8 8.1e-08 1.8 8.105e-08 0 8.25e-08 0 8.255e-08 0 8.4e-08 0 8.405e-08 0 8.55e-08 0 8.555e-08 0 8.7e-08 0 8.705e-08 1.8 8.85e-08 1.8 8.855e-08 1.8 9e-08 1.8 9.005e-08 1.8 9.15e-08 1.8 9.155e-08 1.8 9.3e-08 1.8 9.305e-08 0 9.45e-08 0 9.455e-08 0 9.6e-08 0 9.605e-08 0 9.75e-08 0 9.755e-08 0 9.9e-08 0 9.905e-08 1.8 1.005e-07 1.8 1.005e-07 1.8 1.02e-07 1.8 1.021e-07 1.8 1.035e-07 1.8 1.035e-07 1.8 1.05e-07 1.8 1.051e-07 0 1.065e-07 0 1.065e-07 0 1.08e-07 0 1.081e-07 0 1.095e-07 0 1.095e-07 0 1.11e-07 0 1.111e-07 1.8 1.125e-07 1.8 1.125e-07 1.8 1.14e-07 1.8 1.141e-07 1.8 1.155e-07 1.8 1.155e-07 1.8 1.17e-07 1.8 1.171e-07 0 1.185e-07 0 1.185e-07 0 1.2e-07 0 1.2e-07 0 1.215e-07 0 1.215e-07 0 1.23e-07 0 1.231e-07 1.8 1.245e-07 1.8 1.246e-07 1.8 1.26e-07 1.8 1.26e-07 1.8 1.275e-07 1.8 1.276e-07 1.8 1.29e-07 1.8 1.291e-07 0 1.305e-07 0 1.306e-07 0 1.32e-07 0 1.32e-07 0 1.335e-07 0 1.336e-07 0 1.35e-07 0 1.351e-07 1.8 1.365e-07 1.8 1.366e-07 1.8 1.38e-07 1.8 1.38e-07 1.8 1.395e-07 1.8 1.396e-07 1.8 1.41e-07 1.8 1.411e-07 0 1.425e-07 0 1.426e-07 0 1.44e-07 0 1.44e-07 0 1.455e-07 0 1.456e-07 0 1.47e-07 0 1.471e-07 1.8 1.485e-07 1.8 1.485e-07 1.8 1.5e-07 1.8 1.5e-07 1.8 1.515e-07 1.8 1.516e-07 1.8 1.53e-07 1.8 1.531e-07 0 1.545e-07 0 1.545e-07 0 1.56e-07 0 1.56e-07 0 1.575e-07 0 1.576e-07 0 1.59e-07 0 1.591e-07 1.8 1.605e-07 1.8 1.605e-07 1.8 1.62e-07 1.8 1.62e-07 1.8 1.635e-07 1.8 1.636e-07 1.8 1.65e-07 1.8 1.651e-07 0 1.665e-07 0 1.665e-07 0 1.68e-07 0 1.68e-07 0 1.695e-07 0 1.696e-07 0 1.71e-07 0 1.711e-07 1.8 1.725e-07 1.8 1.725e-07 1.8 1.74e-07 1.8 1.741e-07 1.8 1.755e-07 1.8 1.756e-07 1.8 1.77e-07 1.8 1.771e-07 0 1.785e-07 0 1.785e-07 0 1.8e-07 0 1.801e-07 0 1.815e-07 0 1.816e-07 0 1.83e-07 0 1.831e-07 1.8 1.845e-07 1.8 1.845e-07 1.8 1.86e-07 1.8 1.861e-07 1.8 1.875e-07 1.8 1.876e-07 1.8 1.89e-07 1.8 1.891e-07 0 1.905e-07 0 1.905e-07 0 1.92e-07 0 1.921e-07 0 1.935e-07 0 1.936e-07 0 1.95e-07 0 1.95e-07 1.8 1.965e-07 1.8 1.965e-07 1.8 1.98e-07 1.8 1.981e-07 1.8 1.995e-07 1.8 1.996e-07 1.8 2.01e-07 1.8 2.01e-07 0 2.025e-07 0 2.025e-07 0 2.04e-07 0 2.041e-07 0 2.055e-07 0 2.056e-07 0 2.07e-07 0 2.07e-07 1.8 2.085e-07 1.8 2.085e-07 1.8 2.1e-07 1.8 2.101e-07 1.8 2.115e-07 1.8 2.116e-07 1.8 2.13e-07 1.8 2.13e-07 0 2.145e-07 0 2.145e-07 0 2.16e-07 0 2.161e-07 0 2.175e-07 0 2.176e-07 0 2.19e-07 0 2.19e-07 1.8 2.205e-07 1.8 2.205e-07 1.8 2.22e-07 1.8 2.221e-07 1.8 2.235e-07 1.8 2.236e-07 1.8 2.25e-07 1.8 2.25e-07 0 2.265e-07 0 2.266e-07 0 2.28e-07 0 2.281e-07 0 2.295e-07 0 2.296e-07 0 2.31e-07 0 2.31e-07 1.8 2.325e-07 1.8 2.326e-07 1.8 2.34e-07 1.8 2.341e-07 1.8 2.355e-07 1.8 2.356e-07 1.8 2.37e-07 1.8 2.37e-07 0 2.385e-07 0 2.386e-07 0 2.4e-07 0 2.4e-07 0 2.415e-07 0 2.415e-07 0 2.43e-07 0 2.43e-07 1.8 2.445e-07 1.8 2.446e-07 1.8 2.46e-07 1.8 2.461e-07 1.8 2.475e-07 1.8 2.476e-07 1.8 2.49e-07 1.8 2.491e-07 0 2.505e-07 0 2.505e-07 0 2.52e-07 0 2.52e-07 0 2.535e-07 0 2.535e-07 0 2.55e-07 0 2.55e-07 1.8 2.565e-07 1.8 2.566e-07 1.8 2.58e-07 1.8 2.581e-07 1.8 2.595e-07 1.8 2.596e-07 1.8 2.61e-07 1.8 2.611e-07 0 2.625e-07 0 2.625e-07 0 2.64e-07 0 2.64e-07 0 2.655e-07 0 2.655e-07 0 2.67e-07 0 2.67e-07 1.8 2.685e-07 1.8 2.686e-07 1.8 2.7e-07 1.8 2.701e-07 1.8 2.715e-07 1.8 2.716e-07 1.8 2.73e-07 1.8 2.731e-07 0 2.745e-07 0 2.745e-07 0 2.76e-07 0 2.76e-07 0 2.775e-07 0 2.775e-07 0 2.79e-07 0 2.791e-07 1.8 2.805e-07 1.8 2.806e-07 1.8 2.82e-07 1.8 2.821e-07 1.8 2.835e-07 1.8 2.836e-07 1.8 2.85e-07 1.8 2.851e-07 0 2.865e-07 0 2.865e-07 0 2.88e-07 0 2.88e-07 0 2.895e-07 0 2.895e-07 0 2.91e-07 0 2.911e-07 1.8 2.925e-07 1.8 2.926e-07 1.8 2.94e-07 1.8 2.941e-07 1.8 2.955e-07 1.8 2.956e-07 1.8 2.97e-07 1.8 2.97e-07 0 2.985e-07 0 2.985e-07 0 3e-07 0 3e-07 0 3.015e-07 0 3.015e-07 0 3.03e-07 0 3.031e-07 1.8 3.045e-07 1.8 3.046e-07 1.8 3.06e-07 1.8 3.061e-07 1.8 3.075e-07 1.8 3.076e-07 1.8 3.09e-07 1.8 3.09e-07 0 3.105e-07 0 3.105e-07 0 3.12e-07 0 3.12e-07 0 3.135e-07 0 3.135e-07 0 3.15e-07 0 3.151e-07 1.8 3.165e-07 1.8 3.166e-07 1.8 3.18e-07 1.8 3.181e-07 1.8 3.195e-07 1.8 3.196e-07 1.8 3.21e-07 1.8 3.21e-07 0 3.225e-07 0 3.225e-07 0 3.24e-07 0 3.24e-07 0 3.255e-07 0 3.256e-07 0 3.27e-07 0 3.271e-07 1.8 3.285e-07 1.8 3.286e-07 1.8 3.3e-07 1.8 3.301e-07 1.8 3.315e-07 1.8 3.316e-07 1.8 3.33e-07 1.8 3.33e-07 0 3.345e-07 0 3.345e-07 0 3.36e-07 0 3.36e-07 0 3.375e-07 0 3.376e-07 0 3.39e-07 0 3.391e-07 1.8 3.405e-07 1.8 3.406e-07 1.8 3.42e-07 1.8 3.421e-07 1.8 3.435e-07 1.8 3.435e-07 1.8 3.45e-07 1.8 3.45e-07 0 3.465e-07 0 3.465e-07 0 3.48e-07 0 3.48e-07 0 3.495e-07 0 3.496e-07 0 3.51e-07 0 3.511e-07 1.8 3.525e-07 1.8 3.526e-07 1.8 3.54e-07 1.8 3.541e-07 1.8 3.555e-07 1.8 3.555e-07 1.8 3.57e-07 1.8 3.57e-07 0 3.585e-07 0 3.585e-07 0 3.6e-07 0 3.6e-07 0 3.615e-07 0 3.616e-07 0 3.63e-07 0 3.631e-07 1.8 3.645e-07 1.8 3.646e-07 1.8 3.66e-07 1.8 3.661e-07 1.8 3.675e-07 1.8 3.675e-07 1.8 3.69e-07 1.8 3.69e-07 0 3.705e-07 0 3.705e-07 0 3.72e-07 0 3.72e-07 0 3.735e-07 0 3.736e-07 0 3.75e-07 0 3.751e-07 1.8 3.765e-07 1.8 3.766e-07 1.8 3.78e-07 1.8 3.781e-07 1.8 3.795e-07 1.8 3.795e-07 1.8 3.81e-07 1.8 3.81e-07 0 3.825e-07 0 3.825e-07 0 3.84e-07 0 3.841e-07 0 3.855e-07 0 3.856e-07 0 3.87e-07 0 3.871e-07 1.8 3.885e-07 1.8 3.886e-07 1.8 3.9e-07 1.8 3.9e-07 1.8 3.915e-07 1.8 3.915e-07 1.8 3.93e-07 1.8 3.93e-07 0 3.945e-07 0 3.945e-07 0 3.96e-07 0 3.961e-07 0 3.975e-07 0 3.976e-07 0 3.99e-07 0 3.991e-07 1.8 4.005e-07 1.8 4.006e-07 1.8 4.02e-07 1.8 4.02e-07 1.8 4.035e-07 1.8 4.035e-07 1.8 4.05e-07 1.8 4.05e-07 0 4.065e-07 0 4.065e-07 0 4.08e-07 0 4.081e-07 0 4.095e-07 0 4.096e-07 0 4.11e-07 0 4.111e-07 1.8 4.125e-07 1.8 4.126e-07 1.8 4.14e-07 1.8 4.14e-07 1.8 4.155e-07 1.8 4.155e-07 1.8 4.17e-07 1.8 4.17e-07 0 4.185e-07 0 4.185e-07 0 4.2e-07 0 4.201e-07 0 4.215e-07 0 4.216e-07 0 4.23e-07 0 4.231e-07 1.8 4.245e-07 1.8 4.246e-07 1.8 4.26e-07 1.8 4.26e-07 1.8 4.275e-07 1.8 4.275e-07 1.8 4.29e-07 1.8 4.29e-07 0 4.305e-07 0 4.306e-07 0 4.32e-07 0 4.321e-07 0 4.335e-07 0 4.336e-07 0 4.35e-07 0 4.351e-07 1.8 4.365e-07 1.8 4.365e-07 1.8 4.38e-07 1.8 4.38e-07 1.8 4.395e-07 1.8 4.395e-07 1.8 4.41e-07 1.8 4.41e-07 0 4.425e-07 0 4.426e-07 0 4.44e-07 0 4.441e-07 0 4.455e-07 0 4.456e-07 0 4.47e-07 0 4.471e-07 1.8 4.485e-07 1.8 4.485e-07 1.8 4.5e-07 1.8 4.5e-07 1.8 4.515e-07 1.8 4.515e-07 1.8 4.53e-07 1.8 4.53e-07 0 4.545e-07 0 4.546e-07 0 4.56e-07 0 4.561e-07 0 4.575e-07 0 4.576e-07 0 4.59e-07 0 4.591e-07 1.8 4.605e-07 1.8 4.605e-07 1.8 4.62e-07 1.8 4.62e-07 1.8 4.635e-07 1.8 4.635e-07 1.8 4.65e-07 1.8 4.65e-07 0 4.665e-07 0 4.666e-07 0 4.68e-07 0 4.681e-07 0 4.695e-07 0 4.696e-07 0 4.71e-07 0 4.711e-07 1.8 4.725e-07 1.8 4.725e-07 1.8 4.74e-07 1.8 4.74e-07 1.8 4.755e-07 1.8 4.755e-07 1.8 4.77e-07 1.8 4.771e-07 0 4.785e-07 0 4.785e-07 0 4.8e-07 0 4.8e-07 0 4.815e-07 0 4.815e-07 0 4.83e-07 0 4.83e-07 1.8 4.845e-07 1.8 4.845e-07 1.8 4.86e-07 1.8 4.86e-07 1.8 4.875e-07 1.8 4.875e-07 1.8 4.89e-07 1.8 4.891e-07 0 4.905e-07 0 4.906e-07 0 4.92e-07 0 4.921e-07 0 4.935e-07 0 4.936e-07 0 4.95e-07 0 4.951e-07 1.8 4.965e-07 1.8 4.966e-07 1.8 4.98e-07 1.8 4.981e-07 1.8 4.995e-07 1.8 4.996e-07 1.8 5.01e-07 1.8 5.01e-07 0 5.025e-07 0 5.025e-07 0 5.04e-07 0 5.04e-07 0 5.055e-07 0 5.055e-07 0 5.07e-07 0 5.07e-07 1.8 5.085e-07 1.8 5.085e-07 1.8 5.1e-07 1.8 5.1e-07 1.8 5.115e-07 1.8 5.115e-07 1.8 5.13e-07 1.8 5.131e-07 0 5.145e-07 0 5.146e-07 0 5.16e-07 0 5.161e-07 0 5.175e-07 0 5.176e-07 0 5.19e-07 0 5.191e-07 1.8 5.205e-07 1.8 5.206e-07 1.8 5.22e-07 1.8 5.221e-07 1.8 5.235e-07 1.8 5.236e-07 1.8 5.25e-07 1.8 5.25e-07 0 5.265e-07 0 5.265e-07 0 5.28e-07 0 5.28e-07 0 5.295e-07 0 5.295e-07 0 5.31e-07 0 5.31e-07 1.8 5.325e-07 1.8 5.325e-07 1.8 5.34e-07 1.8 5.34e-07 1.8 5.355e-07 1.8 5.356e-07 1.8 5.37e-07 1.8 5.371e-07 0 5.385e-07 0 5.386e-07 0 5.4e-07 0 5.401e-07 0 5.415e-07 0 5.416e-07 0 5.43e-07 0 5.431e-07 1.8 5.445e-07 1.8 5.446e-07 1.8 5.46e-07 1.8 5.461e-07 1.8 5.475e-07 1.8 5.475e-07 1.8 5.49e-07 1.8 5.49e-07 0 5.505e-07 0 5.505e-07 0 5.52e-07 0 5.52e-07 0 5.535e-07 0 5.535e-07 0 5.55e-07 0 5.55e-07 1.8 5.565e-07 1.8 5.565e-07 1.8 5.58e-07 1.8 5.58e-07 1.8 5.595e-07 1.8 5.596e-07 1.8 5.61e-07 1.8 5.611e-07 0 5.625e-07 0 5.626e-07 0 5.64e-07 0 5.641e-07 0 5.655e-07 0 5.656e-07 0 5.67e-07 0 5.671e-07 1.8 5.685e-07 1.8 5.686e-07 1.8 5.7e-07 1.8 5.701e-07 1.8 5.715e-07 1.8 5.715e-07 1.8 5.73e-07 1.8 5.73e-07 0 5.745e-07 0 5.745e-07 0 5.76e-07 0 5.76e-07 0 5.775e-07 0 5.775e-07 0 5.79e-07 0 5.79e-07 1.8 5.805e-07 1.8 5.805e-07 1.8 5.82e-07 1.8 5.821e-07 1.8 5.835e-07 1.8 5.836e-07 1.8 5.85e-07 1.8 5.851e-07 0 5.865e-07 0 5.866e-07 0 5.88e-07 0 5.881e-07 0 5.895e-07 0 5.896e-07 0 5.91e-07 0 5.911e-07 1.8 5.925e-07 1.8 5.926e-07 1.8 5.94e-07 1.8 5.94e-07 1.8 5.955e-07 1.8 5.955e-07 1.8 5.97e-07 1.8 5.97e-07 0 5.985e-07 0 5.985e-07 0 6e-07 0 6e-07 0 6.015e-07 0 6.015e-07 0 6.03e-07 0 6.03e-07 1.8 6.045e-07 1.8 6.045e-07 1.8 6.06e-07 1.8 6.061e-07 1.8 6.075e-07 1.8 6.076e-07 1.8 6.09e-07 1.8 6.091e-07 0 6.105e-07 0 6.106e-07 0 6.12e-07 0 6.121e-07 0 6.135e-07 0 6.136e-07 0 6.15e-07 0 6.151e-07 1.8 6.165e-07 1.8 6.166e-07 1.8 6.18e-07 1.8 6.18e-07 1.8 6.195e-07 1.8 6.195e-07 1.8 6.21e-07 1.8 6.21e-07 0 6.225e-07 0 6.225e-07 0 6.24e-07 0 6.24e-07 0 6.255e-07 0 6.255e-07 0 6.27e-07 0 6.27e-07 1.8 6.285e-07 1.8 6.286e-07 1.8 6.3e-07 1.8 6.301e-07 1.8 6.315e-07 1.8 6.316e-07 1.8 6.33e-07 1.8 6.331e-07 0 6.345e-07 0 6.346e-07 0 6.36e-07 0 6.361e-07 0 6.375e-07 0 6.376e-07 0 6.39e-07 0 6.391e-07 1.8 6.405e-07 1.8 6.405e-07 1.8 6.42e-07 1.8 6.42e-07 1.8 6.435e-07 1.8 6.435e-07 1.8 6.45e-07 1.8 6.45e-07 0 6.465e-07 0 6.465e-07 0 6.48e-07 0 6.48e-07 0 6.495e-07 0 6.495e-07 0 6.51e-07 0 6.51e-07 1.8 6.525e-07 1.8 6.526e-07 1.8 6.54e-07 1.8 6.541e-07 1.8 6.555e-07 1.8 6.556e-07 1.8 6.57e-07 1.8 6.571e-07 0 6.585e-07 0 6.586e-07 0 6.6e-07 0 6.601e-07 0 6.615e-07 0 6.616e-07 0 6.63e-07 0 6.631e-07 1.8 6.645e-07 1.8 6.645e-07 1.8 6.66e-07 1.8 6.66e-07 1.8 6.675e-07 1.8 6.675e-07 1.8 6.69e-07 1.8 6.69e-07 0 6.705e-07 0 6.705e-07 0 6.72e-07 0 6.72e-07 0 6.735e-07 0 6.735e-07 0 6.75e-07 0 6.75e-07 1.8 6.765e-07 1.8 6.766e-07 1.8 6.78e-07 1.8 6.781e-07 1.8 6.795e-07 1.8 6.796e-07 1.8 6.81e-07 1.8 6.811e-07 0 6.825e-07 0 6.826e-07 0 6.84e-07 0 6.841e-07 0 6.855e-07 0 6.856e-07 0 6.87e-07 0 6.87e-07 1.8 6.885e-07 1.8 6.885e-07 1.8 6.9e-07 1.8 6.9e-07 1.8 6.915e-07 1.8 6.915e-07 1.8 6.93e-07 1.8 6.93e-07 0 6.945e-07 0 6.945e-07 0 6.96e-07 0 6.96e-07 0 6.975e-07 0 6.975e-07 0 6.99e-07 0 6.991e-07 1.8 7.005e-07 1.8 7.006e-07 1.8 7.02e-07 1.8 7.021e-07 1.8 7.035e-07 1.8 7.036e-07 1.8 7.05e-07 1.8 7.051e-07 0 7.065e-07 0 7.066e-07 0 7.08e-07 0 7.081e-07 0 7.095e-07 0 7.096e-07 0 7.11e-07 0 7.11e-07 1.8 7.125e-07 1.8 7.125e-07 1.8 7.14e-07 1.8 7.14e-07 1.8 7.155e-07 1.8 7.155e-07 1.8 7.17e-07 1.8 7.17e-07 0 7.185e-07 0 7.185e-07 0 7.2e-07 0 7.2e-07 0 7.215e-07 0 7.215e-07 0 7.23e-07 0 7.231e-07 1.8 7.245e-07 1.8 7.246e-07 1.8 7.26e-07 1.8 7.261e-07 1.8 7.275e-07 1.8 7.276e-07 1.8 7.29e-07 1.8 7.291e-07 0 7.305e-07 0 7.306e-07 0 7.32e-07 0 7.321e-07 0 7.335e-07 0 7.335e-07 0 7.35e-07 0 7.35e-07 1.8 7.365e-07 1.8 7.365e-07 1.8 7.38e-07 1.8 7.38e-07 1.8 7.395e-07 1.8 7.395e-07 1.8 7.41e-07 1.8 7.41e-07 0 7.425e-07 0 7.425e-07 0 7.44e-07 0 7.44e-07 0 7.455e-07 0 7.456e-07 0 7.47e-07 0 7.471e-07 1.8 7.485e-07 1.8 7.486e-07 1.8 7.5e-07 1.8 7.501e-07 1.8 7.515e-07 1.8 7.516e-07 1.8 7.53e-07 1.8 7.531e-07 0 7.545e-07 0 7.546e-07 0 7.56e-07 0 7.561e-07 0 7.575e-07 0 7.575e-07 0 7.59e-07 0 7.59e-07 1.8 7.605e-07 1.8 7.605e-07 1.8 7.62e-07 1.8 7.62e-07 1.8 7.635e-07 1.8 7.635e-07 1.8 7.65e-07 1.8 7.65e-07 0 7.665e-07 0 7.665e-07 0)
VA2 A2 0 PWL(0 0 1.5e-09 0 1.55e-09 0 3e-09 0 3.05e-09 0 4.5e-09 0 4.55e-09 0 6e-09 0 6.05e-09 1.8 7.5e-09 1.8 7.55e-09 1.8 9e-09 1.8 9.05e-09 1.8 1.05e-08 1.8 1.055e-08 1.8 1.2e-08 1.8 1.205e-08 1.8 1.35e-08 1.8 1.355e-08 1.8 1.5e-08 1.8 1.505e-08 1.8 1.65e-08 1.8 1.655e-08 1.8 1.8e-08 1.8 1.805e-08 0 1.95e-08 0 1.955e-08 0 2.1e-08 0 2.105e-08 0 2.25e-08 0 2.255e-08 0 2.4e-08 0 2.405e-08 0 2.55e-08 0 2.555e-08 0 2.7e-08 0 2.705e-08 0 2.85e-08 0 2.855e-08 0 3e-08 0 3.005e-08 1.8 3.15e-08 1.8 3.155e-08 1.8 3.3e-08 1.8 3.305e-08 1.8 3.45e-08 1.8 3.455e-08 1.8 3.6e-08 1.8 3.605e-08 1.8 3.75e-08 1.8 3.755e-08 1.8 3.9e-08 1.8 3.905e-08 1.8 4.05e-08 1.8 4.055e-08 1.8 4.2e-08 1.8 4.205e-08 0 4.35e-08 0 4.355e-08 0 4.5e-08 0 4.505e-08 0 4.65e-08 0 4.655e-08 0 4.8e-08 0 4.805e-08 0 4.95e-08 0 4.955e-08 0 5.1e-08 0 5.105e-08 0 5.25e-08 0 5.255e-08 0 5.4e-08 0 5.405e-08 1.8 5.55e-08 1.8 5.555e-08 1.8 5.7e-08 1.8 5.705e-08 1.8 5.85e-08 1.8 5.855e-08 1.8 6e-08 1.8 6.005e-08 1.8 6.15e-08 1.8 6.155e-08 1.8 6.3e-08 1.8 6.305e-08 1.8 6.45e-08 1.8 6.455e-08 1.8 6.6e-08 1.8 6.605e-08 0 6.75e-08 0 6.755e-08 0 6.9e-08 0 6.905e-08 0 7.05e-08 0 7.055e-08 0 7.2e-08 0 7.205e-08 0 7.35e-08 0 7.355e-08 0 7.5e-08 0 7.505e-08 0 7.65e-08 0 7.655e-08 0 7.8e-08 0 7.805e-08 1.8 7.95e-08 1.8 7.955e-08 1.8 8.1e-08 1.8 8.105e-08 1.8 8.25e-08 1.8 8.255e-08 1.8 8.4e-08 1.8 8.405e-08 1.8 8.55e-08 1.8 8.555e-08 1.8 8.7e-08 1.8 8.705e-08 1.8 8.85e-08 1.8 8.855e-08 1.8 9e-08 1.8 9.005e-08 0 9.15e-08 0 9.155e-08 0 9.3e-08 0 9.305e-08 0 9.45e-08 0 9.455e-08 0 9.6e-08 0 9.605e-08 0 9.75e-08 0 9.755e-08 0 9.9e-08 0 9.905e-08 0 1.005e-07 0 1.005e-07 0 1.02e-07 0 1.021e-07 1.8 1.035e-07 1.8 1.035e-07 1.8 1.05e-07 1.8 1.051e-07 1.8 1.065e-07 1.8 1.065e-07 1.8 1.08e-07 1.8 1.081e-07 1.8 1.095e-07 1.8 1.095e-07 1.8 1.11e-07 1.8 1.111e-07 1.8 1.125e-07 1.8 1.125e-07 1.8 1.14e-07 1.8 1.141e-07 0 1.155e-07 0 1.155e-07 0 1.17e-07 0 1.171e-07 0 1.185e-07 0 1.185e-07 0 1.2e-07 0 1.2e-07 0 1.215e-07 0 1.215e-07 0 1.23e-07 0 1.231e-07 0 1.245e-07 0 1.246e-07 0 1.26e-07 0 1.26e-07 1.8 1.275e-07 1.8 1.276e-07 1.8 1.29e-07 1.8 1.291e-07 1.8 1.305e-07 1.8 1.306e-07 1.8 1.32e-07 1.8 1.32e-07 1.8 1.335e-07 1.8 1.336e-07 1.8 1.35e-07 1.8 1.351e-07 1.8 1.365e-07 1.8 1.366e-07 1.8 1.38e-07 1.8 1.38e-07 0 1.395e-07 0 1.396e-07 0 1.41e-07 0 1.411e-07 0 1.425e-07 0 1.426e-07 0 1.44e-07 0 1.44e-07 0 1.455e-07 0 1.456e-07 0 1.47e-07 0 1.471e-07 0 1.485e-07 0 1.485e-07 0 1.5e-07 0 1.5e-07 1.8 1.515e-07 1.8 1.516e-07 1.8 1.53e-07 1.8 1.531e-07 1.8 1.545e-07 1.8 1.545e-07 1.8 1.56e-07 1.8 1.56e-07 1.8 1.575e-07 1.8 1.576e-07 1.8 1.59e-07 1.8 1.591e-07 1.8 1.605e-07 1.8 1.605e-07 1.8 1.62e-07 1.8 1.62e-07 0 1.635e-07 0 1.636e-07 0 1.65e-07 0 1.651e-07 0 1.665e-07 0 1.665e-07 0 1.68e-07 0 1.68e-07 0 1.695e-07 0 1.696e-07 0 1.71e-07 0 1.711e-07 0 1.725e-07 0 1.725e-07 0 1.74e-07 0 1.741e-07 1.8 1.755e-07 1.8 1.756e-07 1.8 1.77e-07 1.8 1.771e-07 1.8 1.785e-07 1.8 1.785e-07 1.8 1.8e-07 1.8 1.801e-07 1.8 1.815e-07 1.8 1.816e-07 1.8 1.83e-07 1.8 1.831e-07 1.8 1.845e-07 1.8 1.845e-07 1.8 1.86e-07 1.8 1.861e-07 0 1.875e-07 0 1.876e-07 0 1.89e-07 0 1.891e-07 0 1.905e-07 0 1.905e-07 0 1.92e-07 0 1.921e-07 0 1.935e-07 0 1.936e-07 0 1.95e-07 0 1.95e-07 0 1.965e-07 0 1.965e-07 0 1.98e-07 0 1.981e-07 1.8 1.995e-07 1.8 1.996e-07 1.8 2.01e-07 1.8 2.01e-07 1.8 2.025e-07 1.8 2.025e-07 1.8 2.04e-07 1.8 2.041e-07 1.8 2.055e-07 1.8 2.056e-07 1.8 2.07e-07 1.8 2.07e-07 1.8 2.085e-07 1.8 2.085e-07 1.8 2.1e-07 1.8 2.101e-07 0 2.115e-07 0 2.116e-07 0 2.13e-07 0 2.13e-07 0 2.145e-07 0 2.145e-07 0 2.16e-07 0 2.161e-07 0 2.175e-07 0 2.176e-07 0 2.19e-07 0 2.19e-07 0 2.205e-07 0 2.205e-07 0 2.22e-07 0 2.221e-07 1.8 2.235e-07 1.8 2.236e-07 1.8 2.25e-07 1.8 2.25e-07 1.8 2.265e-07 1.8 2.266e-07 1.8 2.28e-07 1.8 2.281e-07 1.8 2.295e-07 1.8 2.296e-07 1.8 2.31e-07 1.8 2.31e-07 1.8 2.325e-07 1.8 2.326e-07 1.8 2.34e-07 1.8 2.341e-07 0 2.355e-07 0 2.356e-07 0 2.37e-07 0 2.37e-07 0 2.385e-07 0 2.386e-07 0 2.4e-07 0 2.4e-07 0 2.415e-07 0 2.415e-07 0 2.43e-07 0 2.43e-07 0 2.445e-07 0 2.446e-07 0 2.46e-07 0 2.461e-07 1.8 2.475e-07 1.8 2.476e-07 1.8 2.49e-07 1.8 2.491e-07 1.8 2.505e-07 1.8 2.505e-07 1.8 2.52e-07 1.8 2.52e-07 1.8 2.535e-07 1.8 2.535e-07 1.8 2.55e-07 1.8 2.55e-07 1.8 2.565e-07 1.8 2.566e-07 1.8 2.58e-07 1.8 2.581e-07 0 2.595e-07 0 2.596e-07 0 2.61e-07 0 2.611e-07 0 2.625e-07 0 2.625e-07 0 2.64e-07 0 2.64e-07 0 2.655e-07 0 2.655e-07 0 2.67e-07 0 2.67e-07 0 2.685e-07 0 2.686e-07 0 2.7e-07 0 2.701e-07 1.8 2.715e-07 1.8 2.716e-07 1.8 2.73e-07 1.8 2.731e-07 1.8 2.745e-07 1.8 2.745e-07 1.8 2.76e-07 1.8 2.76e-07 1.8 2.775e-07 1.8 2.775e-07 1.8 2.79e-07 1.8 2.791e-07 1.8 2.805e-07 1.8 2.806e-07 1.8 2.82e-07 1.8 2.821e-07 0 2.835e-07 0 2.836e-07 0 2.85e-07 0 2.851e-07 0 2.865e-07 0 2.865e-07 0 2.88e-07 0 2.88e-07 0 2.895e-07 0 2.895e-07 0 2.91e-07 0 2.911e-07 0 2.925e-07 0 2.926e-07 0 2.94e-07 0 2.941e-07 1.8 2.955e-07 1.8 2.956e-07 1.8 2.97e-07 1.8 2.97e-07 1.8 2.985e-07 1.8 2.985e-07 1.8 3e-07 1.8 3e-07 1.8 3.015e-07 1.8 3.015e-07 1.8 3.03e-07 1.8 3.031e-07 1.8 3.045e-07 1.8 3.046e-07 1.8 3.06e-07 1.8 3.061e-07 0 3.075e-07 0 3.076e-07 0 3.09e-07 0 3.09e-07 0 3.105e-07 0 3.105e-07 0 3.12e-07 0 3.12e-07 0 3.135e-07 0 3.135e-07 0 3.15e-07 0 3.151e-07 0 3.165e-07 0 3.166e-07 0 3.18e-07 0 3.181e-07 1.8 3.195e-07 1.8 3.196e-07 1.8 3.21e-07 1.8 3.21e-07 1.8 3.225e-07 1.8 3.225e-07 1.8 3.24e-07 1.8 3.24e-07 1.8 3.255e-07 1.8 3.256e-07 1.8 3.27e-07 1.8 3.271e-07 1.8 3.285e-07 1.8 3.286e-07 1.8 3.3e-07 1.8 3.301e-07 0 3.315e-07 0 3.316e-07 0 3.33e-07 0 3.33e-07 0 3.345e-07 0 3.345e-07 0 3.36e-07 0 3.36e-07 0 3.375e-07 0 3.376e-07 0 3.39e-07 0 3.391e-07 0 3.405e-07 0 3.406e-07 0 3.42e-07 0 3.421e-07 1.8 3.435e-07 1.8 3.435e-07 1.8 3.45e-07 1.8 3.45e-07 1.8 3.465e-07 1.8 3.465e-07 1.8 3.48e-07 1.8 3.48e-07 1.8 3.495e-07 1.8 3.496e-07 1.8 3.51e-07 1.8 3.511e-07 1.8 3.525e-07 1.8 3.526e-07 1.8 3.54e-07 1.8 3.541e-07 0 3.555e-07 0 3.555e-07 0 3.57e-07 0 3.57e-07 0 3.585e-07 0 3.585e-07 0 3.6e-07 0 3.6e-07 0 3.615e-07 0 3.616e-07 0 3.63e-07 0 3.631e-07 0 3.645e-07 0 3.646e-07 0 3.66e-07 0 3.661e-07 1.8 3.675e-07 1.8 3.675e-07 1.8 3.69e-07 1.8 3.69e-07 1.8 3.705e-07 1.8 3.705e-07 1.8 3.72e-07 1.8 3.72e-07 1.8 3.735e-07 1.8 3.736e-07 1.8 3.75e-07 1.8 3.751e-07 1.8 3.765e-07 1.8 3.766e-07 1.8 3.78e-07 1.8 3.781e-07 0 3.795e-07 0 3.795e-07 0 3.81e-07 0 3.81e-07 0 3.825e-07 0 3.825e-07 0 3.84e-07 0 3.841e-07 0 3.855e-07 0 3.856e-07 0 3.87e-07 0 3.871e-07 0 3.885e-07 0 3.886e-07 0 3.9e-07 0 3.9e-07 1.8 3.915e-07 1.8 3.915e-07 1.8 3.93e-07 1.8 3.93e-07 1.8 3.945e-07 1.8 3.945e-07 1.8 3.96e-07 1.8 3.961e-07 1.8 3.975e-07 1.8 3.976e-07 1.8 3.99e-07 1.8 3.991e-07 1.8 4.005e-07 1.8 4.006e-07 1.8 4.02e-07 1.8 4.02e-07 0 4.035e-07 0 4.035e-07 0 4.05e-07 0 4.05e-07 0 4.065e-07 0 4.065e-07 0 4.08e-07 0 4.081e-07 0 4.095e-07 0 4.096e-07 0 4.11e-07 0 4.111e-07 0 4.125e-07 0 4.126e-07 0 4.14e-07 0 4.14e-07 1.8 4.155e-07 1.8 4.155e-07 1.8 4.17e-07 1.8 4.17e-07 1.8 4.185e-07 1.8 4.185e-07 1.8 4.2e-07 1.8 4.201e-07 1.8 4.215e-07 1.8 4.216e-07 1.8 4.23e-07 1.8 4.231e-07 1.8 4.245e-07 1.8 4.246e-07 1.8 4.26e-07 1.8 4.26e-07 0 4.275e-07 0 4.275e-07 0 4.29e-07 0 4.29e-07 0 4.305e-07 0 4.306e-07 0 4.32e-07 0 4.321e-07 0 4.335e-07 0 4.336e-07 0 4.35e-07 0 4.351e-07 0 4.365e-07 0 4.365e-07 0 4.38e-07 0 4.38e-07 1.8 4.395e-07 1.8 4.395e-07 1.8 4.41e-07 1.8 4.41e-07 1.8 4.425e-07 1.8 4.426e-07 1.8 4.44e-07 1.8 4.441e-07 1.8 4.455e-07 1.8 4.456e-07 1.8 4.47e-07 1.8 4.471e-07 1.8 4.485e-07 1.8 4.485e-07 1.8 4.5e-07 1.8 4.5e-07 0 4.515e-07 0 4.515e-07 0 4.53e-07 0 4.53e-07 0 4.545e-07 0 4.546e-07 0 4.56e-07 0 4.561e-07 0 4.575e-07 0 4.576e-07 0 4.59e-07 0 4.591e-07 0 4.605e-07 0 4.605e-07 0 4.62e-07 0 4.62e-07 1.8 4.635e-07 1.8 4.635e-07 1.8 4.65e-07 1.8 4.65e-07 1.8 4.665e-07 1.8 4.666e-07 1.8 4.68e-07 1.8 4.681e-07 1.8 4.695e-07 1.8 4.696e-07 1.8 4.71e-07 1.8 4.711e-07 1.8 4.725e-07 1.8 4.725e-07 1.8 4.74e-07 1.8 4.74e-07 0 4.755e-07 0 4.755e-07 0 4.77e-07 0 4.771e-07 0 4.785e-07 0 4.785e-07 0 4.8e-07 0 4.8e-07 0 4.815e-07 0 4.815e-07 0 4.83e-07 0 4.83e-07 0 4.845e-07 0 4.845e-07 0 4.86e-07 0 4.86e-07 1.8 4.875e-07 1.8 4.875e-07 1.8 4.89e-07 1.8 4.891e-07 1.8 4.905e-07 1.8 4.906e-07 1.8 4.92e-07 1.8 4.921e-07 1.8 4.935e-07 1.8 4.936e-07 1.8 4.95e-07 1.8 4.951e-07 1.8 4.965e-07 1.8 4.966e-07 1.8 4.98e-07 1.8 4.981e-07 0 4.995e-07 0 4.996e-07 0 5.01e-07 0 5.01e-07 0 5.025e-07 0 5.025e-07 0 5.04e-07 0 5.04e-07 0 5.055e-07 0 5.055e-07 0 5.07e-07 0 5.07e-07 0 5.085e-07 0 5.085e-07 0 5.1e-07 0 5.1e-07 1.8 5.115e-07 1.8 5.115e-07 1.8 5.13e-07 1.8 5.131e-07 1.8 5.145e-07 1.8 5.146e-07 1.8 5.16e-07 1.8 5.161e-07 1.8 5.175e-07 1.8 5.176e-07 1.8 5.19e-07 1.8 5.191e-07 1.8 5.205e-07 1.8 5.206e-07 1.8 5.22e-07 1.8 5.221e-07 0 5.235e-07 0 5.236e-07 0 5.25e-07 0 5.25e-07 0 5.265e-07 0 5.265e-07 0 5.28e-07 0 5.28e-07 0 5.295e-07 0 5.295e-07 0 5.31e-07 0 5.31e-07 0 5.325e-07 0 5.325e-07 0 5.34e-07 0 5.34e-07 1.8 5.355e-07 1.8 5.356e-07 1.8 5.37e-07 1.8 5.371e-07 1.8 5.385e-07 1.8 5.386e-07 1.8 5.4e-07 1.8 5.401e-07 1.8 5.415e-07 1.8 5.416e-07 1.8 5.43e-07 1.8 5.431e-07 1.8 5.445e-07 1.8 5.446e-07 1.8 5.46e-07 1.8 5.461e-07 0 5.475e-07 0 5.475e-07 0 5.49e-07 0 5.49e-07 0 5.505e-07 0 5.505e-07 0 5.52e-07 0 5.52e-07 0 5.535e-07 0 5.535e-07 0 5.55e-07 0 5.55e-07 0 5.565e-07 0 5.565e-07 0 5.58e-07 0 5.58e-07 1.8 5.595e-07 1.8 5.596e-07 1.8 5.61e-07 1.8 5.611e-07 1.8 5.625e-07 1.8 5.626e-07 1.8 5.64e-07 1.8 5.641e-07 1.8 5.655e-07 1.8 5.656e-07 1.8 5.67e-07 1.8 5.671e-07 1.8 5.685e-07 1.8 5.686e-07 1.8 5.7e-07 1.8 5.701e-07 0 5.715e-07 0 5.715e-07 0 5.73e-07 0 5.73e-07 0 5.745e-07 0 5.745e-07 0 5.76e-07 0 5.76e-07 0 5.775e-07 0 5.775e-07 0 5.79e-07 0 5.79e-07 0 5.805e-07 0 5.805e-07 0 5.82e-07 0 5.821e-07 1.8 5.835e-07 1.8 5.836e-07 1.8 5.85e-07 1.8 5.851e-07 1.8 5.865e-07 1.8 5.866e-07 1.8 5.88e-07 1.8 5.881e-07 1.8 5.895e-07 1.8 5.896e-07 1.8 5.91e-07 1.8 5.911e-07 1.8 5.925e-07 1.8 5.926e-07 1.8 5.94e-07 1.8 5.94e-07 0 5.955e-07 0 5.955e-07 0 5.97e-07 0 5.97e-07 0 5.985e-07 0 5.985e-07 0 6e-07 0 6e-07 0 6.015e-07 0 6.015e-07 0 6.03e-07 0 6.03e-07 0 6.045e-07 0 6.045e-07 0 6.06e-07 0 6.061e-07 1.8 6.075e-07 1.8 6.076e-07 1.8 6.09e-07 1.8 6.091e-07 1.8 6.105e-07 1.8 6.106e-07 1.8 6.12e-07 1.8 6.121e-07 1.8 6.135e-07 1.8 6.136e-07 1.8 6.15e-07 1.8 6.151e-07 1.8 6.165e-07 1.8 6.166e-07 1.8 6.18e-07 1.8 6.18e-07 0 6.195e-07 0 6.195e-07 0 6.21e-07 0 6.21e-07 0 6.225e-07 0 6.225e-07 0 6.24e-07 0 6.24e-07 0 6.255e-07 0 6.255e-07 0 6.27e-07 0 6.27e-07 0 6.285e-07 0 6.286e-07 0 6.3e-07 0 6.301e-07 1.8 6.315e-07 1.8 6.316e-07 1.8 6.33e-07 1.8 6.331e-07 1.8 6.345e-07 1.8 6.346e-07 1.8 6.36e-07 1.8 6.361e-07 1.8 6.375e-07 1.8 6.376e-07 1.8 6.39e-07 1.8 6.391e-07 1.8 6.405e-07 1.8 6.405e-07 1.8 6.42e-07 1.8 6.42e-07 0 6.435e-07 0 6.435e-07 0 6.45e-07 0 6.45e-07 0 6.465e-07 0 6.465e-07 0 6.48e-07 0 6.48e-07 0 6.495e-07 0 6.495e-07 0 6.51e-07 0 6.51e-07 0 6.525e-07 0 6.526e-07 0 6.54e-07 0 6.541e-07 1.8 6.555e-07 1.8 6.556e-07 1.8 6.57e-07 1.8 6.571e-07 1.8 6.585e-07 1.8 6.586e-07 1.8 6.6e-07 1.8 6.601e-07 1.8 6.615e-07 1.8 6.616e-07 1.8 6.63e-07 1.8 6.631e-07 1.8 6.645e-07 1.8 6.645e-07 1.8 6.66e-07 1.8 6.66e-07 0 6.675e-07 0 6.675e-07 0 6.69e-07 0 6.69e-07 0 6.705e-07 0 6.705e-07 0 6.72e-07 0 6.72e-07 0 6.735e-07 0 6.735e-07 0 6.75e-07 0 6.75e-07 0 6.765e-07 0 6.766e-07 0 6.78e-07 0 6.781e-07 1.8 6.795e-07 1.8 6.796e-07 1.8 6.81e-07 1.8 6.811e-07 1.8 6.825e-07 1.8 6.826e-07 1.8 6.84e-07 1.8 6.841e-07 1.8 6.855e-07 1.8 6.856e-07 1.8 6.87e-07 1.8 6.87e-07 1.8 6.885e-07 1.8 6.885e-07 1.8 6.9e-07 1.8 6.9e-07 0 6.915e-07 0 6.915e-07 0 6.93e-07 0 6.93e-07 0 6.945e-07 0 6.945e-07 0 6.96e-07 0 6.96e-07 0 6.975e-07 0 6.975e-07 0 6.99e-07 0 6.991e-07 0 7.005e-07 0 7.006e-07 0 7.02e-07 0 7.021e-07 1.8 7.035e-07 1.8 7.036e-07 1.8 7.05e-07 1.8 7.051e-07 1.8 7.065e-07 1.8 7.066e-07 1.8 7.08e-07 1.8 7.081e-07 1.8 7.095e-07 1.8 7.096e-07 1.8 7.11e-07 1.8 7.11e-07 1.8 7.125e-07 1.8 7.125e-07 1.8 7.14e-07 1.8 7.14e-07 0 7.155e-07 0 7.155e-07 0 7.17e-07 0 7.17e-07 0 7.185e-07 0 7.185e-07 0 7.2e-07 0 7.2e-07 0 7.215e-07 0 7.215e-07 0 7.23e-07 0 7.231e-07 0 7.245e-07 0 7.246e-07 0 7.26e-07 0 7.261e-07 1.8 7.275e-07 1.8 7.276e-07 1.8 7.29e-07 1.8 7.291e-07 1.8 7.305e-07 1.8 7.306e-07 1.8 7.32e-07 1.8 7.321e-07 1.8 7.335e-07 1.8 7.335e-07 1.8 7.35e-07 1.8 7.35e-07 1.8 7.365e-07 1.8 7.365e-07 1.8 7.38e-07 1.8 7.38e-07 0 7.395e-07 0 7.395e-07 0 7.41e-07 0 7.41e-07 0 7.425e-07 0 7.425e-07 0 7.44e-07 0 7.44e-07 0 7.455e-07 0 7.456e-07 0 7.47e-07 0 7.471e-07 0 7.485e-07 0 7.486e-07 0 7.5e-07 0 7.501e-07 1.8 7.515e-07 1.8 7.516e-07 1.8 7.53e-07 1.8 7.531e-07 1.8 7.545e-07 1.8 7.546e-07 1.8 7.56e-07 1.8 7.561e-07 1.8 7.575e-07 1.8 7.575e-07 1.8 7.59e-07 1.8 7.59e-07 1.8 7.605e-07 1.8 7.605e-07 1.8 7.62e-07 1.8 7.62e-07 0 7.635e-07 0 7.635e-07 0 7.65e-07 0 7.65e-07 0 7.665e-07 0 7.665e-07 0)
VA3 A3 0 PWL(0 0 1.5e-09 0 1.55e-09 0 3e-09 0 3.05e-09 0 4.5e-09 0 4.55e-09 0 6e-09 0 6.05e-09 0 7.5e-09 0 7.55e-09 0 9e-09 0 9.05e-09 0 1.05e-08 0 1.055e-08 0 1.2e-08 0 1.205e-08 1.8 1.35e-08 1.8 1.355e-08 1.8 1.5e-08 1.8 1.505e-08 1.8 1.65e-08 1.8 1.655e-08 1.8 1.8e-08 1.8 1.805e-08 1.8 1.95e-08 1.8 1.955e-08 1.8 2.1e-08 1.8 2.105e-08 1.8 2.25e-08 1.8 2.255e-08 1.8 2.4e-08 1.8 2.405e-08 1.8 2.55e-08 1.8 2.555e-08 1.8 2.7e-08 1.8 2.705e-08 1.8 2.85e-08 1.8 2.855e-08 1.8 3e-08 1.8 3.005e-08 1.8 3.15e-08 1.8 3.155e-08 1.8 3.3e-08 1.8 3.305e-08 1.8 3.45e-08 1.8 3.455e-08 1.8 3.6e-08 1.8 3.605e-08 0 3.75e-08 0 3.755e-08 0 3.9e-08 0 3.905e-08 0 4.05e-08 0 4.055e-08 0 4.2e-08 0 4.205e-08 0 4.35e-08 0 4.355e-08 0 4.5e-08 0 4.505e-08 0 4.65e-08 0 4.655e-08 0 4.8e-08 0 4.805e-08 0 4.95e-08 0 4.955e-08 0 5.1e-08 0 5.105e-08 0 5.25e-08 0 5.255e-08 0 5.4e-08 0 5.405e-08 0 5.55e-08 0 5.555e-08 0 5.7e-08 0 5.705e-08 0 5.85e-08 0 5.855e-08 0 6e-08 0 6.005e-08 1.8 6.15e-08 1.8 6.155e-08 1.8 6.3e-08 1.8 6.305e-08 1.8 6.45e-08 1.8 6.455e-08 1.8 6.6e-08 1.8 6.605e-08 1.8 6.75e-08 1.8 6.755e-08 1.8 6.9e-08 1.8 6.905e-08 1.8 7.05e-08 1.8 7.055e-08 1.8 7.2e-08 1.8 7.205e-08 1.8 7.35e-08 1.8 7.355e-08 1.8 7.5e-08 1.8 7.505e-08 1.8 7.65e-08 1.8 7.655e-08 1.8 7.8e-08 1.8 7.805e-08 1.8 7.95e-08 1.8 7.955e-08 1.8 8.1e-08 1.8 8.105e-08 1.8 8.25e-08 1.8 8.255e-08 1.8 8.4e-08 1.8 8.405e-08 0 8.55e-08 0 8.555e-08 0 8.7e-08 0 8.705e-08 0 8.85e-08 0 8.855e-08 0 9e-08 0 9.005e-08 0 9.15e-08 0 9.155e-08 0 9.3e-08 0 9.305e-08 0 9.45e-08 0 9.455e-08 0 9.6e-08 0 9.605e-08 0 9.75e-08 0 9.755e-08 0 9.9e-08 0 9.905e-08 0 1.005e-07 0 1.005e-07 0 1.02e-07 0 1.021e-07 0 1.035e-07 0 1.035e-07 0 1.05e-07 0 1.051e-07 0 1.065e-07 0 1.065e-07 0 1.08e-07 0 1.081e-07 1.8 1.095e-07 1.8 1.095e-07 1.8 1.11e-07 1.8 1.111e-07 1.8 1.125e-07 1.8 1.125e-07 1.8 1.14e-07 1.8 1.141e-07 1.8 1.155e-07 1.8 1.155e-07 1.8 1.17e-07 1.8 1.171e-07 1.8 1.185e-07 1.8 1.185e-07 1.8 1.2e-07 1.8 1.2e-07 1.8 1.215e-07 1.8 1.215e-07 1.8 1.23e-07 1.8 1.231e-07 1.8 1.245e-07 1.8 1.246e-07 1.8 1.26e-07 1.8 1.26e-07 1.8 1.275e-07 1.8 1.276e-07 1.8 1.29e-07 1.8 1.291e-07 1.8 1.305e-07 1.8 1.306e-07 1.8 1.32e-07 1.8 1.32e-07 0 1.335e-07 0 1.336e-07 0 1.35e-07 0 1.351e-07 0 1.365e-07 0 1.366e-07 0 1.38e-07 0 1.38e-07 0 1.395e-07 0 1.396e-07 0 1.41e-07 0 1.411e-07 0 1.425e-07 0 1.426e-07 0 1.44e-07 0 1.44e-07 0 1.455e-07 0 1.456e-07 0 1.47e-07 0 1.471e-07 0 1.485e-07 0 1.485e-07 0 1.5e-07 0 1.5e-07 0 1.515e-07 0 1.516e-07 0 1.53e-07 0 1.531e-07 0 1.545e-07 0 1.545e-07 0 1.56e-07 0 1.56e-07 1.8 1.575e-07 1.8 1.576e-07 1.8 1.59e-07 1.8 1.591e-07 1.8 1.605e-07 1.8 1.605e-07 1.8 1.62e-07 1.8 1.62e-07 1.8 1.635e-07 1.8 1.636e-07 1.8 1.65e-07 1.8 1.651e-07 1.8 1.665e-07 1.8 1.665e-07 1.8 1.68e-07 1.8 1.68e-07 1.8 1.695e-07 1.8 1.696e-07 1.8 1.71e-07 1.8 1.711e-07 1.8 1.725e-07 1.8 1.725e-07 1.8 1.74e-07 1.8 1.741e-07 1.8 1.755e-07 1.8 1.756e-07 1.8 1.77e-07 1.8 1.771e-07 1.8 1.785e-07 1.8 1.785e-07 1.8 1.8e-07 1.8 1.801e-07 0 1.815e-07 0 1.816e-07 0 1.83e-07 0 1.831e-07 0 1.845e-07 0 1.845e-07 0 1.86e-07 0 1.861e-07 0 1.875e-07 0 1.876e-07 0 1.89e-07 0 1.891e-07 0 1.905e-07 0 1.905e-07 0 1.92e-07 0 1.921e-07 0 1.935e-07 0 1.936e-07 0 1.95e-07 0 1.95e-07 0 1.965e-07 0 1.965e-07 0 1.98e-07 0 1.981e-07 0 1.995e-07 0 1.996e-07 0 2.01e-07 0 2.01e-07 0 2.025e-07 0 2.025e-07 0 2.04e-07 0 2.041e-07 1.8 2.055e-07 1.8 2.056e-07 1.8 2.07e-07 1.8 2.07e-07 1.8 2.085e-07 1.8 2.085e-07 1.8 2.1e-07 1.8 2.101e-07 1.8 2.115e-07 1.8 2.116e-07 1.8 2.13e-07 1.8 2.13e-07 1.8 2.145e-07 1.8 2.145e-07 1.8 2.16e-07 1.8 2.161e-07 1.8 2.175e-07 1.8 2.176e-07 1.8 2.19e-07 1.8 2.19e-07 1.8 2.205e-07 1.8 2.205e-07 1.8 2.22e-07 1.8 2.221e-07 1.8 2.235e-07 1.8 2.236e-07 1.8 2.25e-07 1.8 2.25e-07 1.8 2.265e-07 1.8 2.266e-07 1.8 2.28e-07 1.8 2.281e-07 0 2.295e-07 0 2.296e-07 0 2.31e-07 0 2.31e-07 0 2.325e-07 0 2.326e-07 0 2.34e-07 0 2.341e-07 0 2.355e-07 0 2.356e-07 0 2.37e-07 0 2.37e-07 0 2.385e-07 0 2.386e-07 0 2.4e-07 0 2.4e-07 0 2.415e-07 0 2.415e-07 0 2.43e-07 0 2.43e-07 0 2.445e-07 0 2.446e-07 0 2.46e-07 0 2.461e-07 0 2.475e-07 0 2.476e-07 0 2.49e-07 0 2.491e-07 0 2.505e-07 0 2.505e-07 0 2.52e-07 0 2.52e-07 1.8 2.535e-07 1.8 2.535e-07 1.8 2.55e-07 1.8 2.55e-07 1.8 2.565e-07 1.8 2.566e-07 1.8 2.58e-07 1.8 2.581e-07 1.8 2.595e-07 1.8 2.596e-07 1.8 2.61e-07 1.8 2.611e-07 1.8 2.625e-07 1.8 2.625e-07 1.8 2.64e-07 1.8 2.64e-07 1.8 2.655e-07 1.8 2.655e-07 1.8 2.67e-07 1.8 2.67e-07 1.8 2.685e-07 1.8 2.686e-07 1.8 2.7e-07 1.8 2.701e-07 1.8 2.715e-07 1.8 2.716e-07 1.8 2.73e-07 1.8 2.731e-07 1.8 2.745e-07 1.8 2.745e-07 1.8 2.76e-07 1.8 2.76e-07 0 2.775e-07 0 2.775e-07 0 2.79e-07 0 2.791e-07 0 2.805e-07 0 2.806e-07 0 2.82e-07 0 2.821e-07 0 2.835e-07 0 2.836e-07 0 2.85e-07 0 2.851e-07 0 2.865e-07 0 2.865e-07 0 2.88e-07 0 2.88e-07 0 2.895e-07 0 2.895e-07 0 2.91e-07 0 2.911e-07 0 2.925e-07 0 2.926e-07 0 2.94e-07 0 2.941e-07 0 2.955e-07 0 2.956e-07 0 2.97e-07 0 2.97e-07 0 2.985e-07 0 2.985e-07 0 3e-07 0 3e-07 1.8 3.015e-07 1.8 3.015e-07 1.8 3.03e-07 1.8 3.031e-07 1.8 3.045e-07 1.8 3.046e-07 1.8 3.06e-07 1.8 3.061e-07 1.8 3.075e-07 1.8 3.076e-07 1.8 3.09e-07 1.8 3.09e-07 1.8 3.105e-07 1.8 3.105e-07 1.8 3.12e-07 1.8 3.12e-07 1.8 3.135e-07 1.8 3.135e-07 1.8 3.15e-07 1.8 3.151e-07 1.8 3.165e-07 1.8 3.166e-07 1.8 3.18e-07 1.8 3.181e-07 1.8 3.195e-07 1.8 3.196e-07 1.8 3.21e-07 1.8 3.21e-07 1.8 3.225e-07 1.8 3.225e-07 1.8 3.24e-07 1.8 3.24e-07 0 3.255e-07 0 3.256e-07 0 3.27e-07 0 3.271e-07 0 3.285e-07 0 3.286e-07 0 3.3e-07 0 3.301e-07 0 3.315e-07 0 3.316e-07 0 3.33e-07 0 3.33e-07 0 3.345e-07 0 3.345e-07 0 3.36e-07 0 3.36e-07 0 3.375e-07 0 3.376e-07 0 3.39e-07 0 3.391e-07 0 3.405e-07 0 3.406e-07 0 3.42e-07 0 3.421e-07 0 3.435e-07 0 3.435e-07 0 3.45e-07 0 3.45e-07 0 3.465e-07 0 3.465e-07 0 3.48e-07 0 3.48e-07 1.8 3.495e-07 1.8 3.496e-07 1.8 3.51e-07 1.8 3.511e-07 1.8 3.525e-07 1.8 3.526e-07 1.8 3.54e-07 1.8 3.541e-07 1.8 3.555e-07 1.8 3.555e-07 1.8 3.57e-07 1.8 3.57e-07 1.8 3.585e-07 1.8 3.585e-07 1.8 3.6e-07 1.8 3.6e-07 1.8 3.615e-07 1.8 3.616e-07 1.8 3.63e-07 1.8 3.631e-07 1.8 3.645e-07 1.8 3.646e-07 1.8 3.66e-07 1.8 3.661e-07 1.8 3.675e-07 1.8 3.675e-07 1.8 3.69e-07 1.8 3.69e-07 1.8 3.705e-07 1.8 3.705e-07 1.8 3.72e-07 1.8 3.72e-07 0 3.735e-07 0 3.736e-07 0 3.75e-07 0 3.751e-07 0 3.765e-07 0 3.766e-07 0 3.78e-07 0 3.781e-07 0 3.795e-07 0 3.795e-07 0 3.81e-07 0 3.81e-07 0 3.825e-07 0 3.825e-07 0 3.84e-07 0 3.841e-07 0 3.855e-07 0 3.856e-07 0 3.87e-07 0 3.871e-07 0 3.885e-07 0 3.886e-07 0 3.9e-07 0 3.9e-07 0 3.915e-07 0 3.915e-07 0 3.93e-07 0 3.93e-07 0 3.945e-07 0 3.945e-07 0 3.96e-07 0 3.961e-07 1.8 3.975e-07 1.8 3.976e-07 1.8 3.99e-07 1.8 3.991e-07 1.8 4.005e-07 1.8 4.006e-07 1.8 4.02e-07 1.8 4.02e-07 1.8 4.035e-07 1.8 4.035e-07 1.8 4.05e-07 1.8 4.05e-07 1.8 4.065e-07 1.8 4.065e-07 1.8 4.08e-07 1.8 4.081e-07 1.8 4.095e-07 1.8 4.096e-07 1.8 4.11e-07 1.8 4.111e-07 1.8 4.125e-07 1.8 4.126e-07 1.8 4.14e-07 1.8 4.14e-07 1.8 4.155e-07 1.8 4.155e-07 1.8 4.17e-07 1.8 4.17e-07 1.8 4.185e-07 1.8 4.185e-07 1.8 4.2e-07 1.8 4.201e-07 0 4.215e-07 0 4.216e-07 0 4.23e-07 0 4.231e-07 0 4.245e-07 0 4.246e-07 0 4.26e-07 0 4.26e-07 0 4.275e-07 0 4.275e-07 0 4.29e-07 0 4.29e-07 0 4.305e-07 0 4.306e-07 0 4.32e-07 0 4.321e-07 0 4.335e-07 0 4.336e-07 0 4.35e-07 0 4.351e-07 0 4.365e-07 0 4.365e-07 0 4.38e-07 0 4.38e-07 0 4.395e-07 0 4.395e-07 0 4.41e-07 0 4.41e-07 0 4.425e-07 0 4.426e-07 0 4.44e-07 0 4.441e-07 1.8 4.455e-07 1.8 4.456e-07 1.8 4.47e-07 1.8 4.471e-07 1.8 4.485e-07 1.8 4.485e-07 1.8 4.5e-07 1.8 4.5e-07 1.8 4.515e-07 1.8 4.515e-07 1.8 4.53e-07 1.8 4.53e-07 1.8 4.545e-07 1.8 4.546e-07 1.8 4.56e-07 1.8 4.561e-07 1.8 4.575e-07 1.8 4.576e-07 1.8 4.59e-07 1.8 4.591e-07 1.8 4.605e-07 1.8 4.605e-07 1.8 4.62e-07 1.8 4.62e-07 1.8 4.635e-07 1.8 4.635e-07 1.8 4.65e-07 1.8 4.65e-07 1.8 4.665e-07 1.8 4.666e-07 1.8 4.68e-07 1.8 4.681e-07 0 4.695e-07 0 4.696e-07 0 4.71e-07 0 4.711e-07 0 4.725e-07 0 4.725e-07 0 4.74e-07 0 4.74e-07 0 4.755e-07 0 4.755e-07 0 4.77e-07 0 4.771e-07 0 4.785e-07 0 4.785e-07 0 4.8e-07 0 4.8e-07 0 4.815e-07 0 4.815e-07 0 4.83e-07 0 4.83e-07 0 4.845e-07 0 4.845e-07 0 4.86e-07 0 4.86e-07 0 4.875e-07 0 4.875e-07 0 4.89e-07 0 4.891e-07 0 4.905e-07 0 4.906e-07 0 4.92e-07 0 4.921e-07 1.8 4.935e-07 1.8 4.936e-07 1.8 4.95e-07 1.8 4.951e-07 1.8 4.965e-07 1.8 4.966e-07 1.8 4.98e-07 1.8 4.981e-07 1.8 4.995e-07 1.8 4.996e-07 1.8 5.01e-07 1.8 5.01e-07 1.8 5.025e-07 1.8 5.025e-07 1.8 5.04e-07 1.8 5.04e-07 1.8 5.055e-07 1.8 5.055e-07 1.8 5.07e-07 1.8 5.07e-07 1.8 5.085e-07 1.8 5.085e-07 1.8 5.1e-07 1.8 5.1e-07 1.8 5.115e-07 1.8 5.115e-07 1.8 5.13e-07 1.8 5.131e-07 1.8 5.145e-07 1.8 5.146e-07 1.8 5.16e-07 1.8 5.161e-07 0 5.175e-07 0 5.176e-07 0 5.19e-07 0 5.191e-07 0 5.205e-07 0 5.206e-07 0 5.22e-07 0 5.221e-07 0 5.235e-07 0 5.236e-07 0 5.25e-07 0 5.25e-07 0 5.265e-07 0 5.265e-07 0 5.28e-07 0 5.28e-07 0 5.295e-07 0 5.295e-07 0 5.31e-07 0 5.31e-07 0 5.325e-07 0 5.325e-07 0 5.34e-07 0 5.34e-07 0 5.355e-07 0 5.356e-07 0 5.37e-07 0 5.371e-07 0 5.385e-07 0 5.386e-07 0 5.4e-07 0 5.401e-07 1.8 5.415e-07 1.8 5.416e-07 1.8 5.43e-07 1.8 5.431e-07 1.8 5.445e-07 1.8 5.446e-07 1.8 5.46e-07 1.8 5.461e-07 1.8 5.475e-07 1.8 5.475e-07 1.8 5.49e-07 1.8 5.49e-07 1.8 5.505e-07 1.8 5.505e-07 1.8 5.52e-07 1.8 5.52e-07 1.8 5.535e-07 1.8 5.535e-07 1.8 5.55e-07 1.8 5.55e-07 1.8 5.565e-07 1.8 5.565e-07 1.8 5.58e-07 1.8 5.58e-07 1.8 5.595e-07 1.8 5.596e-07 1.8 5.61e-07 1.8 5.611e-07 1.8 5.625e-07 1.8 5.626e-07 1.8 5.64e-07 1.8 5.641e-07 0 5.655e-07 0 5.656e-07 0 5.67e-07 0 5.671e-07 0 5.685e-07 0 5.686e-07 0 5.7e-07 0 5.701e-07 0 5.715e-07 0 5.715e-07 0 5.73e-07 0 5.73e-07 0 5.745e-07 0 5.745e-07 0 5.76e-07 0 5.76e-07 0 5.775e-07 0 5.775e-07 0 5.79e-07 0 5.79e-07 0 5.805e-07 0 5.805e-07 0 5.82e-07 0 5.821e-07 0 5.835e-07 0 5.836e-07 0 5.85e-07 0 5.851e-07 0 5.865e-07 0 5.866e-07 0 5.88e-07 0 5.881e-07 1.8 5.895e-07 1.8 5.896e-07 1.8 5.91e-07 1.8 5.911e-07 1.8 5.925e-07 1.8 5.926e-07 1.8 5.94e-07 1.8 5.94e-07 1.8 5.955e-07 1.8 5.955e-07 1.8 5.97e-07 1.8 5.97e-07 1.8 5.985e-07 1.8 5.985e-07 1.8 6e-07 1.8 6e-07 1.8 6.015e-07 1.8 6.015e-07 1.8 6.03e-07 1.8 6.03e-07 1.8 6.045e-07 1.8 6.045e-07 1.8 6.06e-07 1.8 6.061e-07 1.8 6.075e-07 1.8 6.076e-07 1.8 6.09e-07 1.8 6.091e-07 1.8 6.105e-07 1.8 6.106e-07 1.8 6.12e-07 1.8 6.121e-07 0 6.135e-07 0 6.136e-07 0 6.15e-07 0 6.151e-07 0 6.165e-07 0 6.166e-07 0 6.18e-07 0 6.18e-07 0 6.195e-07 0 6.195e-07 0 6.21e-07 0 6.21e-07 0 6.225e-07 0 6.225e-07 0 6.24e-07 0 6.24e-07 0 6.255e-07 0 6.255e-07 0 6.27e-07 0 6.27e-07 0 6.285e-07 0 6.286e-07 0 6.3e-07 0 6.301e-07 0 6.315e-07 0 6.316e-07 0 6.33e-07 0 6.331e-07 0 6.345e-07 0 6.346e-07 0 6.36e-07 0 6.361e-07 1.8 6.375e-07 1.8 6.376e-07 1.8 6.39e-07 1.8 6.391e-07 1.8 6.405e-07 1.8 6.405e-07 1.8 6.42e-07 1.8 6.42e-07 1.8 6.435e-07 1.8 6.435e-07 1.8 6.45e-07 1.8 6.45e-07 1.8 6.465e-07 1.8 6.465e-07 1.8 6.48e-07 1.8 6.48e-07 1.8 6.495e-07 1.8 6.495e-07 1.8 6.51e-07 1.8 6.51e-07 1.8 6.525e-07 1.8 6.526e-07 1.8 6.54e-07 1.8 6.541e-07 1.8 6.555e-07 1.8 6.556e-07 1.8 6.57e-07 1.8 6.571e-07 1.8 6.585e-07 1.8 6.586e-07 1.8 6.6e-07 1.8 6.601e-07 0 6.615e-07 0 6.616e-07 0 6.63e-07 0 6.631e-07 0 6.645e-07 0 6.645e-07 0 6.66e-07 0 6.66e-07 0 6.675e-07 0 6.675e-07 0 6.69e-07 0 6.69e-07 0 6.705e-07 0 6.705e-07 0 6.72e-07 0 6.72e-07 0 6.735e-07 0 6.735e-07 0 6.75e-07 0 6.75e-07 0 6.765e-07 0 6.766e-07 0 6.78e-07 0 6.781e-07 0 6.795e-07 0 6.796e-07 0 6.81e-07 0 6.811e-07 0 6.825e-07 0 6.826e-07 0 6.84e-07 0 6.841e-07 1.8 6.855e-07 1.8 6.856e-07 1.8 6.87e-07 1.8 6.87e-07 1.8 6.885e-07 1.8 6.885e-07 1.8 6.9e-07 1.8 6.9e-07 1.8 6.915e-07 1.8 6.915e-07 1.8 6.93e-07 1.8 6.93e-07 1.8 6.945e-07 1.8 6.945e-07 1.8 6.96e-07 1.8 6.96e-07 1.8 6.975e-07 1.8 6.975e-07 1.8 6.99e-07 1.8 6.991e-07 1.8 7.005e-07 1.8 7.006e-07 1.8 7.02e-07 1.8 7.021e-07 1.8 7.035e-07 1.8 7.036e-07 1.8 7.05e-07 1.8 7.051e-07 1.8 7.065e-07 1.8 7.066e-07 1.8 7.08e-07 1.8 7.081e-07 0 7.095e-07 0 7.096e-07 0 7.11e-07 0 7.11e-07 0 7.125e-07 0 7.125e-07 0 7.14e-07 0 7.14e-07 0 7.155e-07 0 7.155e-07 0 7.17e-07 0 7.17e-07 0 7.185e-07 0 7.185e-07 0 7.2e-07 0 7.2e-07 0 7.215e-07 0 7.215e-07 0 7.23e-07 0 7.231e-07 0 7.245e-07 0 7.246e-07 0 7.26e-07 0 7.261e-07 0 7.275e-07 0 7.276e-07 0 7.29e-07 0 7.291e-07 0 7.305e-07 0 7.306e-07 0 7.32e-07 0 7.321e-07 1.8 7.335e-07 1.8 7.335e-07 1.8 7.35e-07 1.8 7.35e-07 1.8 7.365e-07 1.8 7.365e-07 1.8 7.38e-07 1.8 7.38e-07 1.8 7.395e-07 1.8 7.395e-07 1.8 7.41e-07 1.8 7.41e-07 1.8 7.425e-07 1.8 7.425e-07 1.8 7.44e-07 1.8 7.44e-07 1.8 7.455e-07 1.8 7.456e-07 1.8 7.47e-07 1.8 7.471e-07 1.8 7.485e-07 1.8 7.486e-07 1.8 7.5e-07 1.8 7.501e-07 1.8 7.515e-07 1.8 7.516e-07 1.8 7.53e-07 1.8 7.531e-07 1.8 7.545e-07 1.8 7.546e-07 1.8 7.56e-07 1.8 7.561e-07 0 7.575e-07 0 7.575e-07 0 7.59e-07 0 7.59e-07 0 7.605e-07 0 7.605e-07 0 7.62e-07 0 7.62e-07 0 7.635e-07 0 7.635e-07 0 7.65e-07 0 7.65e-07 0 7.665e-07 0 7.665e-07 0)
VB0 B0 0 PWL(0 0 1.5e-09 0 1.55e-09 0 3e-09 0 3.05e-09 0 4.5e-09 0 4.55e-09 0 6e-09 0 6.05e-09 0 7.5e-09 0 7.55e-09 0 9e-09 0 9.05e-09 0 1.05e-08 0 1.055e-08 0 1.2e-08 0 1.205e-08 0 1.35e-08 0 1.355e-08 0 1.5e-08 0 1.505e-08 0 1.65e-08 0 1.655e-08 0 1.8e-08 0 1.805e-08 0 1.95e-08 0 1.955e-08 0 2.1e-08 0 2.105e-08 0 2.25e-08 0 2.255e-08 0 2.4e-08 0 2.405e-08 1.8 2.55e-08 1.8 2.555e-08 1.8 2.7e-08 1.8 2.705e-08 1.8 2.85e-08 1.8 2.855e-08 1.8 3e-08 1.8 3.005e-08 1.8 3.15e-08 1.8 3.155e-08 1.8 3.3e-08 1.8 3.305e-08 1.8 3.45e-08 1.8 3.455e-08 1.8 3.6e-08 1.8 3.605e-08 1.8 3.75e-08 1.8 3.755e-08 1.8 3.9e-08 1.8 3.905e-08 1.8 4.05e-08 1.8 4.055e-08 1.8 4.2e-08 1.8 4.205e-08 1.8 4.35e-08 1.8 4.355e-08 1.8 4.5e-08 1.8 4.505e-08 1.8 4.65e-08 1.8 4.655e-08 1.8 4.8e-08 1.8 4.805e-08 1.8 4.95e-08 1.8 4.955e-08 1.8 5.1e-08 1.8 5.105e-08 1.8 5.25e-08 1.8 5.255e-08 1.8 5.4e-08 1.8 5.405e-08 1.8 5.55e-08 1.8 5.555e-08 1.8 5.7e-08 1.8 5.705e-08 1.8 5.85e-08 1.8 5.855e-08 1.8 6e-08 1.8 6.005e-08 1.8 6.15e-08 1.8 6.155e-08 1.8 6.3e-08 1.8 6.305e-08 1.8 6.45e-08 1.8 6.455e-08 1.8 6.6e-08 1.8 6.605e-08 1.8 6.75e-08 1.8 6.755e-08 1.8 6.9e-08 1.8 6.905e-08 1.8 7.05e-08 1.8 7.055e-08 1.8 7.2e-08 1.8 7.205e-08 0 7.35e-08 0 7.355e-08 0 7.5e-08 0 7.505e-08 0 7.65e-08 0 7.655e-08 0 7.8e-08 0 7.805e-08 0 7.95e-08 0 7.955e-08 0 8.1e-08 0 8.105e-08 0 8.25e-08 0 8.255e-08 0 8.4e-08 0 8.405e-08 0 8.55e-08 0 8.555e-08 0 8.7e-08 0 8.705e-08 0 8.85e-08 0 8.855e-08 0 9e-08 0 9.005e-08 0 9.15e-08 0 9.155e-08 0 9.3e-08 0 9.305e-08 0 9.45e-08 0 9.455e-08 0 9.6e-08 0 9.605e-08 0 9.75e-08 0 9.755e-08 0 9.9e-08 0 9.905e-08 0 1.005e-07 0 1.005e-07 0 1.02e-07 0 1.021e-07 0 1.035e-07 0 1.035e-07 0 1.05e-07 0 1.051e-07 0 1.065e-07 0 1.065e-07 0 1.08e-07 0 1.081e-07 0 1.095e-07 0 1.095e-07 0 1.11e-07 0 1.111e-07 0 1.125e-07 0 1.125e-07 0 1.14e-07 0 1.141e-07 0 1.155e-07 0 1.155e-07 0 1.17e-07 0 1.171e-07 0 1.185e-07 0 1.185e-07 0 1.2e-07 0 1.2e-07 1.8 1.215e-07 1.8 1.215e-07 1.8 1.23e-07 1.8 1.231e-07 1.8 1.245e-07 1.8 1.246e-07 1.8 1.26e-07 1.8 1.26e-07 1.8 1.275e-07 1.8 1.276e-07 1.8 1.29e-07 1.8 1.291e-07 1.8 1.305e-07 1.8 1.306e-07 1.8 1.32e-07 1.8 1.32e-07 1.8 1.335e-07 1.8 1.336e-07 1.8 1.35e-07 1.8 1.351e-07 1.8 1.365e-07 1.8 1.366e-07 1.8 1.38e-07 1.8 1.38e-07 1.8 1.395e-07 1.8 1.396e-07 1.8 1.41e-07 1.8 1.411e-07 1.8 1.425e-07 1.8 1.426e-07 1.8 1.44e-07 1.8 1.44e-07 1.8 1.455e-07 1.8 1.456e-07 1.8 1.47e-07 1.8 1.471e-07 1.8 1.485e-07 1.8 1.485e-07 1.8 1.5e-07 1.8 1.5e-07 1.8 1.515e-07 1.8 1.516e-07 1.8 1.53e-07 1.8 1.531e-07 1.8 1.545e-07 1.8 1.545e-07 1.8 1.56e-07 1.8 1.56e-07 1.8 1.575e-07 1.8 1.576e-07 1.8 1.59e-07 1.8 1.591e-07 1.8 1.605e-07 1.8 1.605e-07 1.8 1.62e-07 1.8 1.62e-07 1.8 1.635e-07 1.8 1.636e-07 1.8 1.65e-07 1.8 1.651e-07 1.8 1.665e-07 1.8 1.665e-07 1.8 1.68e-07 1.8 1.68e-07 0 1.695e-07 0 1.696e-07 0 1.71e-07 0 1.711e-07 0 1.725e-07 0 1.725e-07 0 1.74e-07 0 1.741e-07 0 1.755e-07 0 1.756e-07 0 1.77e-07 0 1.771e-07 0 1.785e-07 0 1.785e-07 0 1.8e-07 0 1.801e-07 0 1.815e-07 0 1.816e-07 0 1.83e-07 0 1.831e-07 0 1.845e-07 0 1.845e-07 0 1.86e-07 0 1.861e-07 0 1.875e-07 0 1.876e-07 0 1.89e-07 0 1.891e-07 0 1.905e-07 0 1.905e-07 0 1.92e-07 0 1.921e-07 0 1.935e-07 0 1.936e-07 0 1.95e-07 0 1.95e-07 0 1.965e-07 0 1.965e-07 0 1.98e-07 0 1.981e-07 0 1.995e-07 0 1.996e-07 0 2.01e-07 0 2.01e-07 0 2.025e-07 0 2.025e-07 0 2.04e-07 0 2.041e-07 0 2.055e-07 0 2.056e-07 0 2.07e-07 0 2.07e-07 0 2.085e-07 0 2.085e-07 0 2.1e-07 0 2.101e-07 0 2.115e-07 0 2.116e-07 0 2.13e-07 0 2.13e-07 0 2.145e-07 0 2.145e-07 0 2.16e-07 0 2.161e-07 1.8 2.175e-07 1.8 2.176e-07 1.8 2.19e-07 1.8 2.19e-07 1.8 2.205e-07 1.8 2.205e-07 1.8 2.22e-07 1.8 2.221e-07 1.8 2.235e-07 1.8 2.236e-07 1.8 2.25e-07 1.8 2.25e-07 1.8 2.265e-07 1.8 2.266e-07 1.8 2.28e-07 1.8 2.281e-07 1.8 2.295e-07 1.8 2.296e-07 1.8 2.31e-07 1.8 2.31e-07 1.8 2.325e-07 1.8 2.326e-07 1.8 2.34e-07 1.8 2.341e-07 1.8 2.355e-07 1.8 2.356e-07 1.8 2.37e-07 1.8 2.37e-07 1.8 2.385e-07 1.8 2.386e-07 1.8 2.4e-07 1.8 2.4e-07 1.8 2.415e-07 1.8 2.415e-07 1.8 2.43e-07 1.8 2.43e-07 1.8 2.445e-07 1.8 2.446e-07 1.8 2.46e-07 1.8 2.461e-07 1.8 2.475e-07 1.8 2.476e-07 1.8 2.49e-07 1.8 2.491e-07 1.8 2.505e-07 1.8 2.505e-07 1.8 2.52e-07 1.8 2.52e-07 1.8 2.535e-07 1.8 2.535e-07 1.8 2.55e-07 1.8 2.55e-07 1.8 2.565e-07 1.8 2.566e-07 1.8 2.58e-07 1.8 2.581e-07 1.8 2.595e-07 1.8 2.596e-07 1.8 2.61e-07 1.8 2.611e-07 1.8 2.625e-07 1.8 2.625e-07 1.8 2.64e-07 1.8 2.64e-07 0 2.655e-07 0 2.655e-07 0 2.67e-07 0 2.67e-07 0 2.685e-07 0 2.686e-07 0 2.7e-07 0 2.701e-07 0 2.715e-07 0 2.716e-07 0 2.73e-07 0 2.731e-07 0 2.745e-07 0 2.745e-07 0 2.76e-07 0 2.76e-07 0 2.775e-07 0 2.775e-07 0 2.79e-07 0 2.791e-07 0 2.805e-07 0 2.806e-07 0 2.82e-07 0 2.821e-07 0 2.835e-07 0 2.836e-07 0 2.85e-07 0 2.851e-07 0 2.865e-07 0 2.865e-07 0 2.88e-07 0 2.88e-07 0 2.895e-07 0 2.895e-07 0 2.91e-07 0 2.911e-07 0 2.925e-07 0 2.926e-07 0 2.94e-07 0 2.941e-07 0 2.955e-07 0 2.956e-07 0 2.97e-07 0 2.97e-07 0 2.985e-07 0 2.985e-07 0 3e-07 0 3e-07 0 3.015e-07 0 3.015e-07 0 3.03e-07 0 3.031e-07 0 3.045e-07 0 3.046e-07 0 3.06e-07 0 3.061e-07 0 3.075e-07 0 3.076e-07 0 3.09e-07 0 3.09e-07 0 3.105e-07 0 3.105e-07 0 3.12e-07 0 3.12e-07 1.8 3.135e-07 1.8 3.135e-07 1.8 3.15e-07 1.8 3.151e-07 1.8 3.165e-07 1.8 3.166e-07 1.8 3.18e-07 1.8 3.181e-07 1.8 3.195e-07 1.8 3.196e-07 1.8 3.21e-07 1.8 3.21e-07 1.8 3.225e-07 1.8 3.225e-07 1.8 3.24e-07 1.8 3.24e-07 1.8 3.255e-07 1.8 3.256e-07 1.8 3.27e-07 1.8 3.271e-07 1.8 3.285e-07 1.8 3.286e-07 1.8 3.3e-07 1.8 3.301e-07 1.8 3.315e-07 1.8 3.316e-07 1.8 3.33e-07 1.8 3.33e-07 1.8 3.345e-07 1.8 3.345e-07 1.8 3.36e-07 1.8 3.36e-07 1.8 3.375e-07 1.8 3.376e-07 1.8 3.39e-07 1.8 3.391e-07 1.8 3.405e-07 1.8 3.406e-07 1.8 3.42e-07 1.8 3.421e-07 1.8 3.435e-07 1.8 3.435e-07 1.8 3.45e-07 1.8 3.45e-07 1.8 3.465e-07 1.8 3.465e-07 1.8 3.48e-07 1.8 3.48e-07 1.8 3.495e-07 1.8 3.496e-07 1.8 3.51e-07 1.8 3.511e-07 1.8 3.525e-07 1.8 3.526e-07 1.8 3.54e-07 1.8 3.541e-07 1.8 3.555e-07 1.8 3.555e-07 1.8 3.57e-07 1.8 3.57e-07 1.8 3.585e-07 1.8 3.585e-07 1.8 3.6e-07 1.8 3.6e-07 0 3.615e-07 0 3.616e-07 0 3.63e-07 0 3.631e-07 0 3.645e-07 0 3.646e-07 0 3.66e-07 0 3.661e-07 0 3.675e-07 0 3.675e-07 0 3.69e-07 0 3.69e-07 0 3.705e-07 0 3.705e-07 0 3.72e-07 0 3.72e-07 0 3.735e-07 0 3.736e-07 0 3.75e-07 0 3.751e-07 0 3.765e-07 0 3.766e-07 0 3.78e-07 0 3.781e-07 0 3.795e-07 0 3.795e-07 0 3.81e-07 0 3.81e-07 0 3.825e-07 0 3.825e-07 0 3.84e-07 0 3.841e-07 0 3.855e-07 0 3.856e-07 0 3.87e-07 0 3.871e-07 0 3.885e-07 0 3.886e-07 0 3.9e-07 0 3.9e-07 0 3.915e-07 0 3.915e-07 0 3.93e-07 0 3.93e-07 0 3.945e-07 0 3.945e-07 0 3.96e-07 0 3.961e-07 0 3.975e-07 0 3.976e-07 0 3.99e-07 0 3.991e-07 0 4.005e-07 0 4.006e-07 0 4.02e-07 0 4.02e-07 0 4.035e-07 0 4.035e-07 0 4.05e-07 0 4.05e-07 0 4.065e-07 0 4.065e-07 0 4.08e-07 0 4.081e-07 1.8 4.095e-07 1.8 4.096e-07 1.8 4.11e-07 1.8 4.111e-07 1.8 4.125e-07 1.8 4.126e-07 1.8 4.14e-07 1.8 4.14e-07 1.8 4.155e-07 1.8 4.155e-07 1.8 4.17e-07 1.8 4.17e-07 1.8 4.185e-07 1.8 4.185e-07 1.8 4.2e-07 1.8 4.201e-07 1.8 4.215e-07 1.8 4.216e-07 1.8 4.23e-07 1.8 4.231e-07 1.8 4.245e-07 1.8 4.246e-07 1.8 4.26e-07 1.8 4.26e-07 1.8 4.275e-07 1.8 4.275e-07 1.8 4.29e-07 1.8 4.29e-07 1.8 4.305e-07 1.8 4.306e-07 1.8 4.32e-07 1.8 4.321e-07 1.8 4.335e-07 1.8 4.336e-07 1.8 4.35e-07 1.8 4.351e-07 1.8 4.365e-07 1.8 4.365e-07 1.8 4.38e-07 1.8 4.38e-07 1.8 4.395e-07 1.8 4.395e-07 1.8 4.41e-07 1.8 4.41e-07 1.8 4.425e-07 1.8 4.426e-07 1.8 4.44e-07 1.8 4.441e-07 1.8 4.455e-07 1.8 4.456e-07 1.8 4.47e-07 1.8 4.471e-07 1.8 4.485e-07 1.8 4.485e-07 1.8 4.5e-07 1.8 4.5e-07 1.8 4.515e-07 1.8 4.515e-07 1.8 4.53e-07 1.8 4.53e-07 1.8 4.545e-07 1.8 4.546e-07 1.8 4.56e-07 1.8 4.561e-07 0 4.575e-07 0 4.576e-07 0 4.59e-07 0 4.591e-07 0 4.605e-07 0 4.605e-07 0 4.62e-07 0 4.62e-07 0 4.635e-07 0 4.635e-07 0 4.65e-07 0 4.65e-07 0 4.665e-07 0 4.666e-07 0 4.68e-07 0 4.681e-07 0 4.695e-07 0 4.696e-07 0 4.71e-07 0 4.711e-07 0 4.725e-07 0 4.725e-07 0 4.74e-07 0 4.74e-07 0 4.755e-07 0 4.755e-07 0 4.77e-07 0 4.771e-07 0 4.785e-07 0 4.785e-07 0 4.8e-07 0 4.8e-07 0 4.815e-07 0 4.815e-07 0 4.83e-07 0 4.83e-07 0 4.845e-07 0 4.845e-07 0 4.86e-07 0 4.86e-07 0 4.875e-07 0 4.875e-07 0 4.89e-07 0 4.891e-07 0 4.905e-07 0 4.906e-07 0 4.92e-07 0 4.921e-07 0 4.935e-07 0 4.936e-07 0 4.95e-07 0 4.951e-07 0 4.965e-07 0 4.966e-07 0 4.98e-07 0 4.981e-07 0 4.995e-07 0 4.996e-07 0 5.01e-07 0 5.01e-07 0 5.025e-07 0 5.025e-07 0 5.04e-07 0 5.04e-07 1.8 5.055e-07 1.8 5.055e-07 1.8 5.07e-07 1.8 5.07e-07 1.8 5.085e-07 1.8 5.085e-07 1.8 5.1e-07 1.8 5.1e-07 1.8 5.115e-07 1.8 5.115e-07 1.8 5.13e-07 1.8 5.131e-07 1.8 5.145e-07 1.8 5.146e-07 1.8 5.16e-07 1.8 5.161e-07 1.8 5.175e-07 1.8 5.176e-07 1.8 5.19e-07 1.8 5.191e-07 1.8 5.205e-07 1.8 5.206e-07 1.8 5.22e-07 1.8 5.221e-07 1.8 5.235e-07 1.8 5.236e-07 1.8 5.25e-07 1.8 5.25e-07 1.8 5.265e-07 1.8 5.265e-07 1.8 5.28e-07 1.8 5.28e-07 1.8 5.295e-07 1.8 5.295e-07 1.8 5.31e-07 1.8 5.31e-07 1.8 5.325e-07 1.8 5.325e-07 1.8 5.34e-07 1.8 5.34e-07 1.8 5.355e-07 1.8 5.356e-07 1.8 5.37e-07 1.8 5.371e-07 1.8 5.385e-07 1.8 5.386e-07 1.8 5.4e-07 1.8 5.401e-07 1.8 5.415e-07 1.8 5.416e-07 1.8 5.43e-07 1.8 5.431e-07 1.8 5.445e-07 1.8 5.446e-07 1.8 5.46e-07 1.8 5.461e-07 1.8 5.475e-07 1.8 5.475e-07 1.8 5.49e-07 1.8 5.49e-07 1.8 5.505e-07 1.8 5.505e-07 1.8 5.52e-07 1.8 5.52e-07 0 5.535e-07 0 5.535e-07 0 5.55e-07 0 5.55e-07 0 5.565e-07 0 5.565e-07 0 5.58e-07 0 5.58e-07 0 5.595e-07 0 5.596e-07 0 5.61e-07 0 5.611e-07 0 5.625e-07 0 5.626e-07 0 5.64e-07 0 5.641e-07 0 5.655e-07 0 5.656e-07 0 5.67e-07 0 5.671e-07 0 5.685e-07 0 5.686e-07 0 5.7e-07 0 5.701e-07 0 5.715e-07 0 5.715e-07 0 5.73e-07 0 5.73e-07 0 5.745e-07 0 5.745e-07 0 5.76e-07 0 5.76e-07 0 5.775e-07 0 5.775e-07 0 5.79e-07 0 5.79e-07 0 5.805e-07 0 5.805e-07 0 5.82e-07 0 5.821e-07 0 5.835e-07 0 5.836e-07 0 5.85e-07 0 5.851e-07 0 5.865e-07 0 5.866e-07 0 5.88e-07 0 5.881e-07 0 5.895e-07 0 5.896e-07 0 5.91e-07 0 5.911e-07 0 5.925e-07 0 5.926e-07 0 5.94e-07 0 5.94e-07 0 5.955e-07 0 5.955e-07 0 5.97e-07 0 5.97e-07 0 5.985e-07 0 5.985e-07 0 6e-07 0 6e-07 1.8 6.015e-07 1.8 6.015e-07 1.8 6.03e-07 1.8 6.03e-07 1.8 6.045e-07 1.8 6.045e-07 1.8 6.06e-07 1.8 6.061e-07 1.8 6.075e-07 1.8 6.076e-07 1.8 6.09e-07 1.8 6.091e-07 1.8 6.105e-07 1.8 6.106e-07 1.8 6.12e-07 1.8 6.121e-07 1.8 6.135e-07 1.8 6.136e-07 1.8 6.15e-07 1.8 6.151e-07 1.8 6.165e-07 1.8 6.166e-07 1.8 6.18e-07 1.8 6.18e-07 1.8 6.195e-07 1.8 6.195e-07 1.8 6.21e-07 1.8 6.21e-07 1.8 6.225e-07 1.8 6.225e-07 1.8 6.24e-07 1.8 6.24e-07 1.8 6.255e-07 1.8 6.255e-07 1.8 6.27e-07 1.8 6.27e-07 1.8 6.285e-07 1.8 6.286e-07 1.8 6.3e-07 1.8 6.301e-07 1.8 6.315e-07 1.8 6.316e-07 1.8 6.33e-07 1.8 6.331e-07 1.8 6.345e-07 1.8 6.346e-07 1.8 6.36e-07 1.8 6.361e-07 1.8 6.375e-07 1.8 6.376e-07 1.8 6.39e-07 1.8 6.391e-07 1.8 6.405e-07 1.8 6.405e-07 1.8 6.42e-07 1.8 6.42e-07 1.8 6.435e-07 1.8 6.435e-07 1.8 6.45e-07 1.8 6.45e-07 1.8 6.465e-07 1.8 6.465e-07 1.8 6.48e-07 1.8 6.48e-07 0 6.495e-07 0 6.495e-07 0 6.51e-07 0 6.51e-07 0 6.525e-07 0 6.526e-07 0 6.54e-07 0 6.541e-07 0 6.555e-07 0 6.556e-07 0 6.57e-07 0 6.571e-07 0 6.585e-07 0 6.586e-07 0 6.6e-07 0 6.601e-07 0 6.615e-07 0 6.616e-07 0 6.63e-07 0 6.631e-07 0 6.645e-07 0 6.645e-07 0 6.66e-07 0 6.66e-07 0 6.675e-07 0 6.675e-07 0 6.69e-07 0 6.69e-07 0 6.705e-07 0 6.705e-07 0 6.72e-07 0 6.72e-07 0 6.735e-07 0 6.735e-07 0 6.75e-07 0 6.75e-07 0 6.765e-07 0 6.766e-07 0 6.78e-07 0 6.781e-07 0 6.795e-07 0 6.796e-07 0 6.81e-07 0 6.811e-07 0 6.825e-07 0 6.826e-07 0 6.84e-07 0 6.841e-07 0 6.855e-07 0 6.856e-07 0 6.87e-07 0 6.87e-07 0 6.885e-07 0 6.885e-07 0 6.9e-07 0 6.9e-07 0 6.915e-07 0 6.915e-07 0 6.93e-07 0 6.93e-07 0 6.945e-07 0 6.945e-07 0 6.96e-07 0 6.96e-07 1.8 6.975e-07 1.8 6.975e-07 1.8 6.99e-07 1.8 6.991e-07 1.8 7.005e-07 1.8 7.006e-07 1.8 7.02e-07 1.8 7.021e-07 1.8 7.035e-07 1.8 7.036e-07 1.8 7.05e-07 1.8 7.051e-07 1.8 7.065e-07 1.8 7.066e-07 1.8 7.08e-07 1.8 7.081e-07 1.8 7.095e-07 1.8 7.096e-07 1.8 7.11e-07 1.8 7.11e-07 1.8 7.125e-07 1.8 7.125e-07 1.8 7.14e-07 1.8 7.14e-07 1.8 7.155e-07 1.8 7.155e-07 1.8 7.17e-07 1.8 7.17e-07 1.8 7.185e-07 1.8 7.185e-07 1.8 7.2e-07 1.8 7.2e-07 1.8 7.215e-07 1.8 7.215e-07 1.8 7.23e-07 1.8 7.231e-07 1.8 7.245e-07 1.8 7.246e-07 1.8 7.26e-07 1.8 7.261e-07 1.8 7.275e-07 1.8 7.276e-07 1.8 7.29e-07 1.8 7.291e-07 1.8 7.305e-07 1.8 7.306e-07 1.8 7.32e-07 1.8 7.321e-07 1.8 7.335e-07 1.8 7.335e-07 1.8 7.35e-07 1.8 7.35e-07 1.8 7.365e-07 1.8 7.365e-07 1.8 7.38e-07 1.8 7.38e-07 1.8 7.395e-07 1.8 7.395e-07 1.8 7.41e-07 1.8 7.41e-07 1.8 7.425e-07 1.8 7.425e-07 1.8 7.44e-07 1.8 7.44e-07 0 7.455e-07 0 7.456e-07 0 7.47e-07 0 7.471e-07 0 7.485e-07 0 7.486e-07 0 7.5e-07 0 7.501e-07 0 7.515e-07 0 7.516e-07 0 7.53e-07 0 7.531e-07 0 7.545e-07 0 7.546e-07 0 7.56e-07 0 7.561e-07 0 7.575e-07 0 7.575e-07 0 7.59e-07 0 7.59e-07 0 7.605e-07 0 7.605e-07 0 7.62e-07 0 7.62e-07 0 7.635e-07 0 7.635e-07 0 7.65e-07 0 7.65e-07 0 7.665e-07 0 7.665e-07 0)
VB1 B1 0 PWL(0 0 1.5e-09 0 1.55e-09 0 3e-09 0 3.05e-09 0 4.5e-09 0 4.55e-09 0 6e-09 0 6.05e-09 0 7.5e-09 0 7.55e-09 0 9e-09 0 9.05e-09 0 1.05e-08 0 1.055e-08 0 1.2e-08 0 1.205e-08 0 1.35e-08 0 1.355e-08 0 1.5e-08 0 1.505e-08 0 1.65e-08 0 1.655e-08 0 1.8e-08 0 1.805e-08 0 1.95e-08 0 1.955e-08 0 2.1e-08 0 2.105e-08 0 2.25e-08 0 2.255e-08 0 2.4e-08 0 2.405e-08 0 2.55e-08 0 2.555e-08 0 2.7e-08 0 2.705e-08 0 2.85e-08 0 2.855e-08 0 3e-08 0 3.005e-08 0 3.15e-08 0 3.155e-08 0 3.3e-08 0 3.305e-08 0 3.45e-08 0 3.455e-08 0 3.6e-08 0 3.605e-08 0 3.75e-08 0 3.755e-08 0 3.9e-08 0 3.905e-08 0 4.05e-08 0 4.055e-08 0 4.2e-08 0 4.205e-08 0 4.35e-08 0 4.355e-08 0 4.5e-08 0 4.505e-08 0 4.65e-08 0 4.655e-08 0 4.8e-08 0 4.805e-08 1.8 4.95e-08 1.8 4.955e-08 1.8 5.1e-08 1.8 5.105e-08 1.8 5.25e-08 1.8 5.255e-08 1.8 5.4e-08 1.8 5.405e-08 1.8 5.55e-08 1.8 5.555e-08 1.8 5.7e-08 1.8 5.705e-08 1.8 5.85e-08 1.8 5.855e-08 1.8 6e-08 1.8 6.005e-08 1.8 6.15e-08 1.8 6.155e-08 1.8 6.3e-08 1.8 6.305e-08 1.8 6.45e-08 1.8 6.455e-08 1.8 6.6e-08 1.8 6.605e-08 1.8 6.75e-08 1.8 6.755e-08 1.8 6.9e-08 1.8 6.905e-08 1.8 7.05e-08 1.8 7.055e-08 1.8 7.2e-08 1.8 7.205e-08 1.8 7.35e-08 1.8 7.355e-08 1.8 7.5e-08 1.8 7.505e-08 1.8 7.65e-08 1.8 7.655e-08 1.8 7.8e-08 1.8 7.805e-08 1.8 7.95e-08 1.8 7.955e-08 1.8 8.1e-08 1.8 8.105e-08 1.8 8.25e-08 1.8 8.255e-08 1.8 8.4e-08 1.8 8.405e-08 1.8 8.55e-08 1.8 8.555e-08 1.8 8.7e-08 1.8 8.705e-08 1.8 8.85e-08 1.8 8.855e-08 1.8 9e-08 1.8 9.005e-08 1.8 9.15e-08 1.8 9.155e-08 1.8 9.3e-08 1.8 9.305e-08 1.8 9.45e-08 1.8 9.455e-08 1.8 9.6e-08 1.8 9.605e-08 1.8 9.75e-08 1.8 9.755e-08 1.8 9.9e-08 1.8 9.905e-08 1.8 1.005e-07 1.8 1.005e-07 1.8 1.02e-07 1.8 1.021e-07 1.8 1.035e-07 1.8 1.035e-07 1.8 1.05e-07 1.8 1.051e-07 1.8 1.065e-07 1.8 1.065e-07 1.8 1.08e-07 1.8 1.081e-07 1.8 1.095e-07 1.8 1.095e-07 1.8 1.11e-07 1.8 1.111e-07 1.8 1.125e-07 1.8 1.125e-07 1.8 1.14e-07 1.8 1.141e-07 1.8 1.155e-07 1.8 1.155e-07 1.8 1.17e-07 1.8 1.171e-07 1.8 1.185e-07 1.8 1.185e-07 1.8 1.2e-07 1.8 1.2e-07 1.8 1.215e-07 1.8 1.215e-07 1.8 1.23e-07 1.8 1.231e-07 1.8 1.245e-07 1.8 1.246e-07 1.8 1.26e-07 1.8 1.26e-07 1.8 1.275e-07 1.8 1.276e-07 1.8 1.29e-07 1.8 1.291e-07 1.8 1.305e-07 1.8 1.306e-07 1.8 1.32e-07 1.8 1.32e-07 1.8 1.335e-07 1.8 1.336e-07 1.8 1.35e-07 1.8 1.351e-07 1.8 1.365e-07 1.8 1.366e-07 1.8 1.38e-07 1.8 1.38e-07 1.8 1.395e-07 1.8 1.396e-07 1.8 1.41e-07 1.8 1.411e-07 1.8 1.425e-07 1.8 1.426e-07 1.8 1.44e-07 1.8 1.44e-07 0 1.455e-07 0 1.456e-07 0 1.47e-07 0 1.471e-07 0 1.485e-07 0 1.485e-07 0 1.5e-07 0 1.5e-07 0 1.515e-07 0 1.516e-07 0 1.53e-07 0 1.531e-07 0 1.545e-07 0 1.545e-07 0 1.56e-07 0 1.56e-07 0 1.575e-07 0 1.576e-07 0 1.59e-07 0 1.591e-07 0 1.605e-07 0 1.605e-07 0 1.62e-07 0 1.62e-07 0 1.635e-07 0 1.636e-07 0 1.65e-07 0 1.651e-07 0 1.665e-07 0 1.665e-07 0 1.68e-07 0 1.68e-07 0 1.695e-07 0 1.696e-07 0 1.71e-07 0 1.711e-07 0 1.725e-07 0 1.725e-07 0 1.74e-07 0 1.741e-07 0 1.755e-07 0 1.756e-07 0 1.77e-07 0 1.771e-07 0 1.785e-07 0 1.785e-07 0 1.8e-07 0 1.801e-07 0 1.815e-07 0 1.816e-07 0 1.83e-07 0 1.831e-07 0 1.845e-07 0 1.845e-07 0 1.86e-07 0 1.861e-07 0 1.875e-07 0 1.876e-07 0 1.89e-07 0 1.891e-07 0 1.905e-07 0 1.905e-07 0 1.92e-07 0 1.921e-07 0 1.935e-07 0 1.936e-07 0 1.95e-07 0 1.95e-07 0 1.965e-07 0 1.965e-07 0 1.98e-07 0 1.981e-07 0 1.995e-07 0 1.996e-07 0 2.01e-07 0 2.01e-07 0 2.025e-07 0 2.025e-07 0 2.04e-07 0 2.041e-07 0 2.055e-07 0 2.056e-07 0 2.07e-07 0 2.07e-07 0 2.085e-07 0 2.085e-07 0 2.1e-07 0 2.101e-07 0 2.115e-07 0 2.116e-07 0 2.13e-07 0 2.13e-07 0 2.145e-07 0 2.145e-07 0 2.16e-07 0 2.161e-07 0 2.175e-07 0 2.176e-07 0 2.19e-07 0 2.19e-07 0 2.205e-07 0 2.205e-07 0 2.22e-07 0 2.221e-07 0 2.235e-07 0 2.236e-07 0 2.25e-07 0 2.25e-07 0 2.265e-07 0 2.266e-07 0 2.28e-07 0 2.281e-07 0 2.295e-07 0 2.296e-07 0 2.31e-07 0 2.31e-07 0 2.325e-07 0 2.326e-07 0 2.34e-07 0 2.341e-07 0 2.355e-07 0 2.356e-07 0 2.37e-07 0 2.37e-07 0 2.385e-07 0 2.386e-07 0 2.4e-07 0 2.4e-07 1.8 2.415e-07 1.8 2.415e-07 1.8 2.43e-07 1.8 2.43e-07 1.8 2.445e-07 1.8 2.446e-07 1.8 2.46e-07 1.8 2.461e-07 1.8 2.475e-07 1.8 2.476e-07 1.8 2.49e-07 1.8 2.491e-07 1.8 2.505e-07 1.8 2.505e-07 1.8 2.52e-07 1.8 2.52e-07 1.8 2.535e-07 1.8 2.535e-07 1.8 2.55e-07 1.8 2.55e-07 1.8 2.565e-07 1.8 2.566e-07 1.8 2.58e-07 1.8 2.581e-07 1.8 2.595e-07 1.8 2.596e-07 1.8 2.61e-07 1.8 2.611e-07 1.8 2.625e-07 1.8 2.625e-07 1.8 2.64e-07 1.8 2.64e-07 1.8 2.655e-07 1.8 2.655e-07 1.8 2.67e-07 1.8 2.67e-07 1.8 2.685e-07 1.8 2.686e-07 1.8 2.7e-07 1.8 2.701e-07 1.8 2.715e-07 1.8 2.716e-07 1.8 2.73e-07 1.8 2.731e-07 1.8 2.745e-07 1.8 2.745e-07 1.8 2.76e-07 1.8 2.76e-07 1.8 2.775e-07 1.8 2.775e-07 1.8 2.79e-07 1.8 2.791e-07 1.8 2.805e-07 1.8 2.806e-07 1.8 2.82e-07 1.8 2.821e-07 1.8 2.835e-07 1.8 2.836e-07 1.8 2.85e-07 1.8 2.851e-07 1.8 2.865e-07 1.8 2.865e-07 1.8 2.88e-07 1.8 2.88e-07 1.8 2.895e-07 1.8 2.895e-07 1.8 2.91e-07 1.8 2.911e-07 1.8 2.925e-07 1.8 2.926e-07 1.8 2.94e-07 1.8 2.941e-07 1.8 2.955e-07 1.8 2.956e-07 1.8 2.97e-07 1.8 2.97e-07 1.8 2.985e-07 1.8 2.985e-07 1.8 3e-07 1.8 3e-07 1.8 3.015e-07 1.8 3.015e-07 1.8 3.03e-07 1.8 3.031e-07 1.8 3.045e-07 1.8 3.046e-07 1.8 3.06e-07 1.8 3.061e-07 1.8 3.075e-07 1.8 3.076e-07 1.8 3.09e-07 1.8 3.09e-07 1.8 3.105e-07 1.8 3.105e-07 1.8 3.12e-07 1.8 3.12e-07 1.8 3.135e-07 1.8 3.135e-07 1.8 3.15e-07 1.8 3.151e-07 1.8 3.165e-07 1.8 3.166e-07 1.8 3.18e-07 1.8 3.181e-07 1.8 3.195e-07 1.8 3.196e-07 1.8 3.21e-07 1.8 3.21e-07 1.8 3.225e-07 1.8 3.225e-07 1.8 3.24e-07 1.8 3.24e-07 1.8 3.255e-07 1.8 3.256e-07 1.8 3.27e-07 1.8 3.271e-07 1.8 3.285e-07 1.8 3.286e-07 1.8 3.3e-07 1.8 3.301e-07 1.8 3.315e-07 1.8 3.316e-07 1.8 3.33e-07 1.8 3.33e-07 1.8 3.345e-07 1.8 3.345e-07 1.8 3.36e-07 1.8 3.36e-07 0 3.375e-07 0 3.376e-07 0 3.39e-07 0 3.391e-07 0 3.405e-07 0 3.406e-07 0 3.42e-07 0 3.421e-07 0 3.435e-07 0 3.435e-07 0 3.45e-07 0 3.45e-07 0 3.465e-07 0 3.465e-07 0 3.48e-07 0 3.48e-07 0 3.495e-07 0 3.496e-07 0 3.51e-07 0 3.511e-07 0 3.525e-07 0 3.526e-07 0 3.54e-07 0 3.541e-07 0 3.555e-07 0 3.555e-07 0 3.57e-07 0 3.57e-07 0 3.585e-07 0 3.585e-07 0 3.6e-07 0 3.6e-07 0 3.615e-07 0 3.616e-07 0 3.63e-07 0 3.631e-07 0 3.645e-07 0 3.646e-07 0 3.66e-07 0 3.661e-07 0 3.675e-07 0 3.675e-07 0 3.69e-07 0 3.69e-07 0 3.705e-07 0 3.705e-07 0 3.72e-07 0 3.72e-07 0 3.735e-07 0 3.736e-07 0 3.75e-07 0 3.751e-07 0 3.765e-07 0 3.766e-07 0 3.78e-07 0 3.781e-07 0 3.795e-07 0 3.795e-07 0 3.81e-07 0 3.81e-07 0 3.825e-07 0 3.825e-07 0 3.84e-07 0 3.841e-07 0 3.855e-07 0 3.856e-07 0 3.87e-07 0 3.871e-07 0 3.885e-07 0 3.886e-07 0 3.9e-07 0 3.9e-07 0 3.915e-07 0 3.915e-07 0 3.93e-07 0 3.93e-07 0 3.945e-07 0 3.945e-07 0 3.96e-07 0 3.961e-07 0 3.975e-07 0 3.976e-07 0 3.99e-07 0 3.991e-07 0 4.005e-07 0 4.006e-07 0 4.02e-07 0 4.02e-07 0 4.035e-07 0 4.035e-07 0 4.05e-07 0 4.05e-07 0 4.065e-07 0 4.065e-07 0 4.08e-07 0 4.081e-07 0 4.095e-07 0 4.096e-07 0 4.11e-07 0 4.111e-07 0 4.125e-07 0 4.126e-07 0 4.14e-07 0 4.14e-07 0 4.155e-07 0 4.155e-07 0 4.17e-07 0 4.17e-07 0 4.185e-07 0 4.185e-07 0 4.2e-07 0 4.201e-07 0 4.215e-07 0 4.216e-07 0 4.23e-07 0 4.231e-07 0 4.245e-07 0 4.246e-07 0 4.26e-07 0 4.26e-07 0 4.275e-07 0 4.275e-07 0 4.29e-07 0 4.29e-07 0 4.305e-07 0 4.306e-07 0 4.32e-07 0 4.321e-07 1.8 4.335e-07 1.8 4.336e-07 1.8 4.35e-07 1.8 4.351e-07 1.8 4.365e-07 1.8 4.365e-07 1.8 4.38e-07 1.8 4.38e-07 1.8 4.395e-07 1.8 4.395e-07 1.8 4.41e-07 1.8 4.41e-07 1.8 4.425e-07 1.8 4.426e-07 1.8 4.44e-07 1.8 4.441e-07 1.8 4.455e-07 1.8 4.456e-07 1.8 4.47e-07 1.8 4.471e-07 1.8 4.485e-07 1.8 4.485e-07 1.8 4.5e-07 1.8 4.5e-07 1.8 4.515e-07 1.8 4.515e-07 1.8 4.53e-07 1.8 4.53e-07 1.8 4.545e-07 1.8 4.546e-07 1.8 4.56e-07 1.8 4.561e-07 1.8 4.575e-07 1.8 4.576e-07 1.8 4.59e-07 1.8 4.591e-07 1.8 4.605e-07 1.8 4.605e-07 1.8 4.62e-07 1.8 4.62e-07 1.8 4.635e-07 1.8 4.635e-07 1.8 4.65e-07 1.8 4.65e-07 1.8 4.665e-07 1.8 4.666e-07 1.8 4.68e-07 1.8 4.681e-07 1.8 4.695e-07 1.8 4.696e-07 1.8 4.71e-07 1.8 4.711e-07 1.8 4.725e-07 1.8 4.725e-07 1.8 4.74e-07 1.8 4.74e-07 1.8 4.755e-07 1.8 4.755e-07 1.8 4.77e-07 1.8 4.771e-07 1.8 4.785e-07 1.8 4.785e-07 1.8 4.8e-07 1.8 4.8e-07 1.8 4.815e-07 1.8 4.815e-07 1.8 4.83e-07 1.8 4.83e-07 1.8 4.845e-07 1.8 4.845e-07 1.8 4.86e-07 1.8 4.86e-07 1.8 4.875e-07 1.8 4.875e-07 1.8 4.89e-07 1.8 4.891e-07 1.8 4.905e-07 1.8 4.906e-07 1.8 4.92e-07 1.8 4.921e-07 1.8 4.935e-07 1.8 4.936e-07 1.8 4.95e-07 1.8 4.951e-07 1.8 4.965e-07 1.8 4.966e-07 1.8 4.98e-07 1.8 4.981e-07 1.8 4.995e-07 1.8 4.996e-07 1.8 5.01e-07 1.8 5.01e-07 1.8 5.025e-07 1.8 5.025e-07 1.8 5.04e-07 1.8 5.04e-07 1.8 5.055e-07 1.8 5.055e-07 1.8 5.07e-07 1.8 5.07e-07 1.8 5.085e-07 1.8 5.085e-07 1.8 5.1e-07 1.8 5.1e-07 1.8 5.115e-07 1.8 5.115e-07 1.8 5.13e-07 1.8 5.131e-07 1.8 5.145e-07 1.8 5.146e-07 1.8 5.16e-07 1.8 5.161e-07 1.8 5.175e-07 1.8 5.176e-07 1.8 5.19e-07 1.8 5.191e-07 1.8 5.205e-07 1.8 5.206e-07 1.8 5.22e-07 1.8 5.221e-07 1.8 5.235e-07 1.8 5.236e-07 1.8 5.25e-07 1.8 5.25e-07 1.8 5.265e-07 1.8 5.265e-07 1.8 5.28e-07 1.8 5.28e-07 0 5.295e-07 0 5.295e-07 0 5.31e-07 0 5.31e-07 0 5.325e-07 0 5.325e-07 0 5.34e-07 0 5.34e-07 0 5.355e-07 0 5.356e-07 0 5.37e-07 0 5.371e-07 0 5.385e-07 0 5.386e-07 0 5.4e-07 0 5.401e-07 0 5.415e-07 0 5.416e-07 0 5.43e-07 0 5.431e-07 0 5.445e-07 0 5.446e-07 0 5.46e-07 0 5.461e-07 0 5.475e-07 0 5.475e-07 0 5.49e-07 0 5.49e-07 0 5.505e-07 0 5.505e-07 0 5.52e-07 0 5.52e-07 0 5.535e-07 0 5.535e-07 0 5.55e-07 0 5.55e-07 0 5.565e-07 0 5.565e-07 0 5.58e-07 0 5.58e-07 0 5.595e-07 0 5.596e-07 0 5.61e-07 0 5.611e-07 0 5.625e-07 0 5.626e-07 0 5.64e-07 0 5.641e-07 0 5.655e-07 0 5.656e-07 0 5.67e-07 0 5.671e-07 0 5.685e-07 0 5.686e-07 0 5.7e-07 0 5.701e-07 0 5.715e-07 0 5.715e-07 0 5.73e-07 0 5.73e-07 0 5.745e-07 0 5.745e-07 0 5.76e-07 0 5.76e-07 0 5.775e-07 0 5.775e-07 0 5.79e-07 0 5.79e-07 0 5.805e-07 0 5.805e-07 0 5.82e-07 0 5.821e-07 0 5.835e-07 0 5.836e-07 0 5.85e-07 0 5.851e-07 0 5.865e-07 0 5.866e-07 0 5.88e-07 0 5.881e-07 0 5.895e-07 0 5.896e-07 0 5.91e-07 0 5.911e-07 0 5.925e-07 0 5.926e-07 0 5.94e-07 0 5.94e-07 0 5.955e-07 0 5.955e-07 0 5.97e-07 0 5.97e-07 0 5.985e-07 0 5.985e-07 0 6e-07 0 6e-07 0 6.015e-07 0 6.015e-07 0 6.03e-07 0 6.03e-07 0 6.045e-07 0 6.045e-07 0 6.06e-07 0 6.061e-07 0 6.075e-07 0 6.076e-07 0 6.09e-07 0 6.091e-07 0 6.105e-07 0 6.106e-07 0 6.12e-07 0 6.121e-07 0 6.135e-07 0 6.136e-07 0 6.15e-07 0 6.151e-07 0 6.165e-07 0 6.166e-07 0 6.18e-07 0 6.18e-07 0 6.195e-07 0 6.195e-07 0 6.21e-07 0 6.21e-07 0 6.225e-07 0 6.225e-07 0 6.24e-07 0 6.24e-07 1.8 6.255e-07 1.8 6.255e-07 1.8 6.27e-07 1.8 6.27e-07 1.8 6.285e-07 1.8 6.286e-07 1.8 6.3e-07 1.8 6.301e-07 1.8 6.315e-07 1.8 6.316e-07 1.8 6.33e-07 1.8 6.331e-07 1.8 6.345e-07 1.8 6.346e-07 1.8 6.36e-07 1.8 6.361e-07 1.8 6.375e-07 1.8 6.376e-07 1.8 6.39e-07 1.8 6.391e-07 1.8 6.405e-07 1.8 6.405e-07 1.8 6.42e-07 1.8 6.42e-07 1.8 6.435e-07 1.8 6.435e-07 1.8 6.45e-07 1.8 6.45e-07 1.8 6.465e-07 1.8 6.465e-07 1.8 6.48e-07 1.8 6.48e-07 1.8 6.495e-07 1.8 6.495e-07 1.8 6.51e-07 1.8 6.51e-07 1.8 6.525e-07 1.8 6.526e-07 1.8 6.54e-07 1.8 6.541e-07 1.8 6.555e-07 1.8 6.556e-07 1.8 6.57e-07 1.8 6.571e-07 1.8 6.585e-07 1.8 6.586e-07 1.8 6.6e-07 1.8 6.601e-07 1.8 6.615e-07 1.8 6.616e-07 1.8 6.63e-07 1.8 6.631e-07 1.8 6.645e-07 1.8 6.645e-07 1.8 6.66e-07 1.8 6.66e-07 1.8 6.675e-07 1.8 6.675e-07 1.8 6.69e-07 1.8 6.69e-07 1.8 6.705e-07 1.8 6.705e-07 1.8 6.72e-07 1.8 6.72e-07 1.8 6.735e-07 1.8 6.735e-07 1.8 6.75e-07 1.8 6.75e-07 1.8 6.765e-07 1.8 6.766e-07 1.8 6.78e-07 1.8 6.781e-07 1.8 6.795e-07 1.8 6.796e-07 1.8 6.81e-07 1.8 6.811e-07 1.8 6.825e-07 1.8 6.826e-07 1.8 6.84e-07 1.8 6.841e-07 1.8 6.855e-07 1.8 6.856e-07 1.8 6.87e-07 1.8 6.87e-07 1.8 6.885e-07 1.8 6.885e-07 1.8 6.9e-07 1.8 6.9e-07 1.8 6.915e-07 1.8 6.915e-07 1.8 6.93e-07 1.8 6.93e-07 1.8 6.945e-07 1.8 6.945e-07 1.8 6.96e-07 1.8 6.96e-07 1.8 6.975e-07 1.8 6.975e-07 1.8 6.99e-07 1.8 6.991e-07 1.8 7.005e-07 1.8 7.006e-07 1.8 7.02e-07 1.8 7.021e-07 1.8 7.035e-07 1.8 7.036e-07 1.8 7.05e-07 1.8 7.051e-07 1.8 7.065e-07 1.8 7.066e-07 1.8 7.08e-07 1.8 7.081e-07 1.8 7.095e-07 1.8 7.096e-07 1.8 7.11e-07 1.8 7.11e-07 1.8 7.125e-07 1.8 7.125e-07 1.8 7.14e-07 1.8 7.14e-07 1.8 7.155e-07 1.8 7.155e-07 1.8 7.17e-07 1.8 7.17e-07 1.8 7.185e-07 1.8 7.185e-07 1.8 7.2e-07 1.8 7.2e-07 0 7.215e-07 0 7.215e-07 0 7.23e-07 0 7.231e-07 0 7.245e-07 0 7.246e-07 0 7.26e-07 0 7.261e-07 0 7.275e-07 0 7.276e-07 0 7.29e-07 0 7.291e-07 0 7.305e-07 0 7.306e-07 0 7.32e-07 0 7.321e-07 0 7.335e-07 0 7.335e-07 0 7.35e-07 0 7.35e-07 0 7.365e-07 0 7.365e-07 0 7.38e-07 0 7.38e-07 0 7.395e-07 0 7.395e-07 0 7.41e-07 0 7.41e-07 0 7.425e-07 0 7.425e-07 0 7.44e-07 0 7.44e-07 0 7.455e-07 0 7.456e-07 0 7.47e-07 0 7.471e-07 0 7.485e-07 0 7.486e-07 0 7.5e-07 0 7.501e-07 0 7.515e-07 0 7.516e-07 0 7.53e-07 0 7.531e-07 0 7.545e-07 0 7.546e-07 0 7.56e-07 0 7.561e-07 0 7.575e-07 0 7.575e-07 0 7.59e-07 0 7.59e-07 0 7.605e-07 0 7.605e-07 0 7.62e-07 0 7.62e-07 0 7.635e-07 0 7.635e-07 0 7.65e-07 0 7.65e-07 0 7.665e-07 0 7.665e-07 0)
VB2 B2 0 PWL(0 0 1.5e-09 0 1.55e-09 0 3e-09 0 3.05e-09 0 4.5e-09 0 4.55e-09 0 6e-09 0 6.05e-09 0 7.5e-09 0 7.55e-09 0 9e-09 0 9.05e-09 0 1.05e-08 0 1.055e-08 0 1.2e-08 0 1.205e-08 0 1.35e-08 0 1.355e-08 0 1.5e-08 0 1.505e-08 0 1.65e-08 0 1.655e-08 0 1.8e-08 0 1.805e-08 0 1.95e-08 0 1.955e-08 0 2.1e-08 0 2.105e-08 0 2.25e-08 0 2.255e-08 0 2.4e-08 0 2.405e-08 0 2.55e-08 0 2.555e-08 0 2.7e-08 0 2.705e-08 0 2.85e-08 0 2.855e-08 0 3e-08 0 3.005e-08 0 3.15e-08 0 3.155e-08 0 3.3e-08 0 3.305e-08 0 3.45e-08 0 3.455e-08 0 3.6e-08 0 3.605e-08 0 3.75e-08 0 3.755e-08 0 3.9e-08 0 3.905e-08 0 4.05e-08 0 4.055e-08 0 4.2e-08 0 4.205e-08 0 4.35e-08 0 4.355e-08 0 4.5e-08 0 4.505e-08 0 4.65e-08 0 4.655e-08 0 4.8e-08 0 4.805e-08 0 4.95e-08 0 4.955e-08 0 5.1e-08 0 5.105e-08 0 5.25e-08 0 5.255e-08 0 5.4e-08 0 5.405e-08 0 5.55e-08 0 5.555e-08 0 5.7e-08 0 5.705e-08 0 5.85e-08 0 5.855e-08 0 6e-08 0 6.005e-08 0 6.15e-08 0 6.155e-08 0 6.3e-08 0 6.305e-08 0 6.45e-08 0 6.455e-08 0 6.6e-08 0 6.605e-08 0 6.75e-08 0 6.755e-08 0 6.9e-08 0 6.905e-08 0 7.05e-08 0 7.055e-08 0 7.2e-08 0 7.205e-08 0 7.35e-08 0 7.355e-08 0 7.5e-08 0 7.505e-08 0 7.65e-08 0 7.655e-08 0 7.8e-08 0 7.805e-08 0 7.95e-08 0 7.955e-08 0 8.1e-08 0 8.105e-08 0 8.25e-08 0 8.255e-08 0 8.4e-08 0 8.405e-08 0 8.55e-08 0 8.555e-08 0 8.7e-08 0 8.705e-08 0 8.85e-08 0 8.855e-08 0 9e-08 0 9.005e-08 0 9.15e-08 0 9.155e-08 0 9.3e-08 0 9.305e-08 0 9.45e-08 0 9.455e-08 0 9.6e-08 0 9.605e-08 1.8 9.75e-08 1.8 9.755e-08 1.8 9.9e-08 1.8 9.905e-08 1.8 1.005e-07 1.8 1.005e-07 1.8 1.02e-07 1.8 1.021e-07 1.8 1.035e-07 1.8 1.035e-07 1.8 1.05e-07 1.8 1.051e-07 1.8 1.065e-07 1.8 1.065e-07 1.8 1.08e-07 1.8 1.081e-07 1.8 1.095e-07 1.8 1.095e-07 1.8 1.11e-07 1.8 1.111e-07 1.8 1.125e-07 1.8 1.125e-07 1.8 1.14e-07 1.8 1.141e-07 1.8 1.155e-07 1.8 1.155e-07 1.8 1.17e-07 1.8 1.171e-07 1.8 1.185e-07 1.8 1.185e-07 1.8 1.2e-07 1.8 1.2e-07 1.8 1.215e-07 1.8 1.215e-07 1.8 1.23e-07 1.8 1.231e-07 1.8 1.245e-07 1.8 1.246e-07 1.8 1.26e-07 1.8 1.26e-07 1.8 1.275e-07 1.8 1.276e-07 1.8 1.29e-07 1.8 1.291e-07 1.8 1.305e-07 1.8 1.306e-07 1.8 1.32e-07 1.8 1.32e-07 1.8 1.335e-07 1.8 1.336e-07 1.8 1.35e-07 1.8 1.351e-07 1.8 1.365e-07 1.8 1.366e-07 1.8 1.38e-07 1.8 1.38e-07 1.8 1.395e-07 1.8 1.396e-07 1.8 1.41e-07 1.8 1.411e-07 1.8 1.425e-07 1.8 1.426e-07 1.8 1.44e-07 1.8 1.44e-07 1.8 1.455e-07 1.8 1.456e-07 1.8 1.47e-07 1.8 1.471e-07 1.8 1.485e-07 1.8 1.485e-07 1.8 1.5e-07 1.8 1.5e-07 1.8 1.515e-07 1.8 1.516e-07 1.8 1.53e-07 1.8 1.531e-07 1.8 1.545e-07 1.8 1.545e-07 1.8 1.56e-07 1.8 1.56e-07 1.8 1.575e-07 1.8 1.576e-07 1.8 1.59e-07 1.8 1.591e-07 1.8 1.605e-07 1.8 1.605e-07 1.8 1.62e-07 1.8 1.62e-07 1.8 1.635e-07 1.8 1.636e-07 1.8 1.65e-07 1.8 1.651e-07 1.8 1.665e-07 1.8 1.665e-07 1.8 1.68e-07 1.8 1.68e-07 1.8 1.695e-07 1.8 1.696e-07 1.8 1.71e-07 1.8 1.711e-07 1.8 1.725e-07 1.8 1.725e-07 1.8 1.74e-07 1.8 1.741e-07 1.8 1.755e-07 1.8 1.756e-07 1.8 1.77e-07 1.8 1.771e-07 1.8 1.785e-07 1.8 1.785e-07 1.8 1.8e-07 1.8 1.801e-07 1.8 1.815e-07 1.8 1.816e-07 1.8 1.83e-07 1.8 1.831e-07 1.8 1.845e-07 1.8 1.845e-07 1.8 1.86e-07 1.8 1.861e-07 1.8 1.875e-07 1.8 1.876e-07 1.8 1.89e-07 1.8 1.891e-07 1.8 1.905e-07 1.8 1.905e-07 1.8 1.92e-07 1.8 1.921e-07 1.8 1.935e-07 1.8 1.936e-07 1.8 1.95e-07 1.8 1.95e-07 1.8 1.965e-07 1.8 1.965e-07 1.8 1.98e-07 1.8 1.981e-07 1.8 1.995e-07 1.8 1.996e-07 1.8 2.01e-07 1.8 2.01e-07 1.8 2.025e-07 1.8 2.025e-07 1.8 2.04e-07 1.8 2.041e-07 1.8 2.055e-07 1.8 2.056e-07 1.8 2.07e-07 1.8 2.07e-07 1.8 2.085e-07 1.8 2.085e-07 1.8 2.1e-07 1.8 2.101e-07 1.8 2.115e-07 1.8 2.116e-07 1.8 2.13e-07 1.8 2.13e-07 1.8 2.145e-07 1.8 2.145e-07 1.8 2.16e-07 1.8 2.161e-07 1.8 2.175e-07 1.8 2.176e-07 1.8 2.19e-07 1.8 2.19e-07 1.8 2.205e-07 1.8 2.205e-07 1.8 2.22e-07 1.8 2.221e-07 1.8 2.235e-07 1.8 2.236e-07 1.8 2.25e-07 1.8 2.25e-07 1.8 2.265e-07 1.8 2.266e-07 1.8 2.28e-07 1.8 2.281e-07 1.8 2.295e-07 1.8 2.296e-07 1.8 2.31e-07 1.8 2.31e-07 1.8 2.325e-07 1.8 2.326e-07 1.8 2.34e-07 1.8 2.341e-07 1.8 2.355e-07 1.8 2.356e-07 1.8 2.37e-07 1.8 2.37e-07 1.8 2.385e-07 1.8 2.386e-07 1.8 2.4e-07 1.8 2.4e-07 1.8 2.415e-07 1.8 2.415e-07 1.8 2.43e-07 1.8 2.43e-07 1.8 2.445e-07 1.8 2.446e-07 1.8 2.46e-07 1.8 2.461e-07 1.8 2.475e-07 1.8 2.476e-07 1.8 2.49e-07 1.8 2.491e-07 1.8 2.505e-07 1.8 2.505e-07 1.8 2.52e-07 1.8 2.52e-07 1.8 2.535e-07 1.8 2.535e-07 1.8 2.55e-07 1.8 2.55e-07 1.8 2.565e-07 1.8 2.566e-07 1.8 2.58e-07 1.8 2.581e-07 1.8 2.595e-07 1.8 2.596e-07 1.8 2.61e-07 1.8 2.611e-07 1.8 2.625e-07 1.8 2.625e-07 1.8 2.64e-07 1.8 2.64e-07 1.8 2.655e-07 1.8 2.655e-07 1.8 2.67e-07 1.8 2.67e-07 1.8 2.685e-07 1.8 2.686e-07 1.8 2.7e-07 1.8 2.701e-07 1.8 2.715e-07 1.8 2.716e-07 1.8 2.73e-07 1.8 2.731e-07 1.8 2.745e-07 1.8 2.745e-07 1.8 2.76e-07 1.8 2.76e-07 1.8 2.775e-07 1.8 2.775e-07 1.8 2.79e-07 1.8 2.791e-07 1.8 2.805e-07 1.8 2.806e-07 1.8 2.82e-07 1.8 2.821e-07 1.8 2.835e-07 1.8 2.836e-07 1.8 2.85e-07 1.8 2.851e-07 1.8 2.865e-07 1.8 2.865e-07 1.8 2.88e-07 1.8 2.88e-07 0 2.895e-07 0 2.895e-07 0 2.91e-07 0 2.911e-07 0 2.925e-07 0 2.926e-07 0 2.94e-07 0 2.941e-07 0 2.955e-07 0 2.956e-07 0 2.97e-07 0 2.97e-07 0 2.985e-07 0 2.985e-07 0 3e-07 0 3e-07 0 3.015e-07 0 3.015e-07 0 3.03e-07 0 3.031e-07 0 3.045e-07 0 3.046e-07 0 3.06e-07 0 3.061e-07 0 3.075e-07 0 3.076e-07 0 3.09e-07 0 3.09e-07 0 3.105e-07 0 3.105e-07 0 3.12e-07 0 3.12e-07 0 3.135e-07 0 3.135e-07 0 3.15e-07 0 3.151e-07 0 3.165e-07 0 3.166e-07 0 3.18e-07 0 3.181e-07 0 3.195e-07 0 3.196e-07 0 3.21e-07 0 3.21e-07 0 3.225e-07 0 3.225e-07 0 3.24e-07 0 3.24e-07 0 3.255e-07 0 3.256e-07 0 3.27e-07 0 3.271e-07 0 3.285e-07 0 3.286e-07 0 3.3e-07 0 3.301e-07 0 3.315e-07 0 3.316e-07 0 3.33e-07 0 3.33e-07 0 3.345e-07 0 3.345e-07 0 3.36e-07 0 3.36e-07 0 3.375e-07 0 3.376e-07 0 3.39e-07 0 3.391e-07 0 3.405e-07 0 3.406e-07 0 3.42e-07 0 3.421e-07 0 3.435e-07 0 3.435e-07 0 3.45e-07 0 3.45e-07 0 3.465e-07 0 3.465e-07 0 3.48e-07 0 3.48e-07 0 3.495e-07 0 3.496e-07 0 3.51e-07 0 3.511e-07 0 3.525e-07 0 3.526e-07 0 3.54e-07 0 3.541e-07 0 3.555e-07 0 3.555e-07 0 3.57e-07 0 3.57e-07 0 3.585e-07 0 3.585e-07 0 3.6e-07 0 3.6e-07 0 3.615e-07 0 3.616e-07 0 3.63e-07 0 3.631e-07 0 3.645e-07 0 3.646e-07 0 3.66e-07 0 3.661e-07 0 3.675e-07 0 3.675e-07 0 3.69e-07 0 3.69e-07 0 3.705e-07 0 3.705e-07 0 3.72e-07 0 3.72e-07 0 3.735e-07 0 3.736e-07 0 3.75e-07 0 3.751e-07 0 3.765e-07 0 3.766e-07 0 3.78e-07 0 3.781e-07 0 3.795e-07 0 3.795e-07 0 3.81e-07 0 3.81e-07 0 3.825e-07 0 3.825e-07 0 3.84e-07 0 3.841e-07 0 3.855e-07 0 3.856e-07 0 3.87e-07 0 3.871e-07 0 3.885e-07 0 3.886e-07 0 3.9e-07 0 3.9e-07 0 3.915e-07 0 3.915e-07 0 3.93e-07 0 3.93e-07 0 3.945e-07 0 3.945e-07 0 3.96e-07 0 3.961e-07 0 3.975e-07 0 3.976e-07 0 3.99e-07 0 3.991e-07 0 4.005e-07 0 4.006e-07 0 4.02e-07 0 4.02e-07 0 4.035e-07 0 4.035e-07 0 4.05e-07 0 4.05e-07 0 4.065e-07 0 4.065e-07 0 4.08e-07 0 4.081e-07 0 4.095e-07 0 4.096e-07 0 4.11e-07 0 4.111e-07 0 4.125e-07 0 4.126e-07 0 4.14e-07 0 4.14e-07 0 4.155e-07 0 4.155e-07 0 4.17e-07 0 4.17e-07 0 4.185e-07 0 4.185e-07 0 4.2e-07 0 4.201e-07 0 4.215e-07 0 4.216e-07 0 4.23e-07 0 4.231e-07 0 4.245e-07 0 4.246e-07 0 4.26e-07 0 4.26e-07 0 4.275e-07 0 4.275e-07 0 4.29e-07 0 4.29e-07 0 4.305e-07 0 4.306e-07 0 4.32e-07 0 4.321e-07 0 4.335e-07 0 4.336e-07 0 4.35e-07 0 4.351e-07 0 4.365e-07 0 4.365e-07 0 4.38e-07 0 4.38e-07 0 4.395e-07 0 4.395e-07 0 4.41e-07 0 4.41e-07 0 4.425e-07 0 4.426e-07 0 4.44e-07 0 4.441e-07 0 4.455e-07 0 4.456e-07 0 4.47e-07 0 4.471e-07 0 4.485e-07 0 4.485e-07 0 4.5e-07 0 4.5e-07 0 4.515e-07 0 4.515e-07 0 4.53e-07 0 4.53e-07 0 4.545e-07 0 4.546e-07 0 4.56e-07 0 4.561e-07 0 4.575e-07 0 4.576e-07 0 4.59e-07 0 4.591e-07 0 4.605e-07 0 4.605e-07 0 4.62e-07 0 4.62e-07 0 4.635e-07 0 4.635e-07 0 4.65e-07 0 4.65e-07 0 4.665e-07 0 4.666e-07 0 4.68e-07 0 4.681e-07 0 4.695e-07 0 4.696e-07 0 4.71e-07 0 4.711e-07 0 4.725e-07 0 4.725e-07 0 4.74e-07 0 4.74e-07 0 4.755e-07 0 4.755e-07 0 4.77e-07 0 4.771e-07 0 4.785e-07 0 4.785e-07 0 4.8e-07 0 4.8e-07 1.8 4.815e-07 1.8 4.815e-07 1.8 4.83e-07 1.8 4.83e-07 1.8 4.845e-07 1.8 4.845e-07 1.8 4.86e-07 1.8 4.86e-07 1.8 4.875e-07 1.8 4.875e-07 1.8 4.89e-07 1.8 4.891e-07 1.8 4.905e-07 1.8 4.906e-07 1.8 4.92e-07 1.8 4.921e-07 1.8 4.935e-07 1.8 4.936e-07 1.8 4.95e-07 1.8 4.951e-07 1.8 4.965e-07 1.8 4.966e-07 1.8 4.98e-07 1.8 4.981e-07 1.8 4.995e-07 1.8 4.996e-07 1.8 5.01e-07 1.8 5.01e-07 1.8 5.025e-07 1.8 5.025e-07 1.8 5.04e-07 1.8 5.04e-07 1.8 5.055e-07 1.8 5.055e-07 1.8 5.07e-07 1.8 5.07e-07 1.8 5.085e-07 1.8 5.085e-07 1.8 5.1e-07 1.8 5.1e-07 1.8 5.115e-07 1.8 5.115e-07 1.8 5.13e-07 1.8 5.131e-07 1.8 5.145e-07 1.8 5.146e-07 1.8 5.16e-07 1.8 5.161e-07 1.8 5.175e-07 1.8 5.176e-07 1.8 5.19e-07 1.8 5.191e-07 1.8 5.205e-07 1.8 5.206e-07 1.8 5.22e-07 1.8 5.221e-07 1.8 5.235e-07 1.8 5.236e-07 1.8 5.25e-07 1.8 5.25e-07 1.8 5.265e-07 1.8 5.265e-07 1.8 5.28e-07 1.8 5.28e-07 1.8 5.295e-07 1.8 5.295e-07 1.8 5.31e-07 1.8 5.31e-07 1.8 5.325e-07 1.8 5.325e-07 1.8 5.34e-07 1.8 5.34e-07 1.8 5.355e-07 1.8 5.356e-07 1.8 5.37e-07 1.8 5.371e-07 1.8 5.385e-07 1.8 5.386e-07 1.8 5.4e-07 1.8 5.401e-07 1.8 5.415e-07 1.8 5.416e-07 1.8 5.43e-07 1.8 5.431e-07 1.8 5.445e-07 1.8 5.446e-07 1.8 5.46e-07 1.8 5.461e-07 1.8 5.475e-07 1.8 5.475e-07 1.8 5.49e-07 1.8 5.49e-07 1.8 5.505e-07 1.8 5.505e-07 1.8 5.52e-07 1.8 5.52e-07 1.8 5.535e-07 1.8 5.535e-07 1.8 5.55e-07 1.8 5.55e-07 1.8 5.565e-07 1.8 5.565e-07 1.8 5.58e-07 1.8 5.58e-07 1.8 5.595e-07 1.8 5.596e-07 1.8 5.61e-07 1.8 5.611e-07 1.8 5.625e-07 1.8 5.626e-07 1.8 5.64e-07 1.8 5.641e-07 1.8 5.655e-07 1.8 5.656e-07 1.8 5.67e-07 1.8 5.671e-07 1.8 5.685e-07 1.8 5.686e-07 1.8 5.7e-07 1.8 5.701e-07 1.8 5.715e-07 1.8 5.715e-07 1.8 5.73e-07 1.8 5.73e-07 1.8 5.745e-07 1.8 5.745e-07 1.8 5.76e-07 1.8 5.76e-07 1.8 5.775e-07 1.8 5.775e-07 1.8 5.79e-07 1.8 5.79e-07 1.8 5.805e-07 1.8 5.805e-07 1.8 5.82e-07 1.8 5.821e-07 1.8 5.835e-07 1.8 5.836e-07 1.8 5.85e-07 1.8 5.851e-07 1.8 5.865e-07 1.8 5.866e-07 1.8 5.88e-07 1.8 5.881e-07 1.8 5.895e-07 1.8 5.896e-07 1.8 5.91e-07 1.8 5.911e-07 1.8 5.925e-07 1.8 5.926e-07 1.8 5.94e-07 1.8 5.94e-07 1.8 5.955e-07 1.8 5.955e-07 1.8 5.97e-07 1.8 5.97e-07 1.8 5.985e-07 1.8 5.985e-07 1.8 6e-07 1.8 6e-07 1.8 6.015e-07 1.8 6.015e-07 1.8 6.03e-07 1.8 6.03e-07 1.8 6.045e-07 1.8 6.045e-07 1.8 6.06e-07 1.8 6.061e-07 1.8 6.075e-07 1.8 6.076e-07 1.8 6.09e-07 1.8 6.091e-07 1.8 6.105e-07 1.8 6.106e-07 1.8 6.12e-07 1.8 6.121e-07 1.8 6.135e-07 1.8 6.136e-07 1.8 6.15e-07 1.8 6.151e-07 1.8 6.165e-07 1.8 6.166e-07 1.8 6.18e-07 1.8 6.18e-07 1.8 6.195e-07 1.8 6.195e-07 1.8 6.21e-07 1.8 6.21e-07 1.8 6.225e-07 1.8 6.225e-07 1.8 6.24e-07 1.8 6.24e-07 1.8 6.255e-07 1.8 6.255e-07 1.8 6.27e-07 1.8 6.27e-07 1.8 6.285e-07 1.8 6.286e-07 1.8 6.3e-07 1.8 6.301e-07 1.8 6.315e-07 1.8 6.316e-07 1.8 6.33e-07 1.8 6.331e-07 1.8 6.345e-07 1.8 6.346e-07 1.8 6.36e-07 1.8 6.361e-07 1.8 6.375e-07 1.8 6.376e-07 1.8 6.39e-07 1.8 6.391e-07 1.8 6.405e-07 1.8 6.405e-07 1.8 6.42e-07 1.8 6.42e-07 1.8 6.435e-07 1.8 6.435e-07 1.8 6.45e-07 1.8 6.45e-07 1.8 6.465e-07 1.8 6.465e-07 1.8 6.48e-07 1.8 6.48e-07 1.8 6.495e-07 1.8 6.495e-07 1.8 6.51e-07 1.8 6.51e-07 1.8 6.525e-07 1.8 6.526e-07 1.8 6.54e-07 1.8 6.541e-07 1.8 6.555e-07 1.8 6.556e-07 1.8 6.57e-07 1.8 6.571e-07 1.8 6.585e-07 1.8 6.586e-07 1.8 6.6e-07 1.8 6.601e-07 1.8 6.615e-07 1.8 6.616e-07 1.8 6.63e-07 1.8 6.631e-07 1.8 6.645e-07 1.8 6.645e-07 1.8 6.66e-07 1.8 6.66e-07 1.8 6.675e-07 1.8 6.675e-07 1.8 6.69e-07 1.8 6.69e-07 1.8 6.705e-07 1.8 6.705e-07 1.8 6.72e-07 1.8 6.72e-07 0 6.735e-07 0 6.735e-07 0 6.75e-07 0 6.75e-07 0 6.765e-07 0 6.766e-07 0 6.78e-07 0 6.781e-07 0 6.795e-07 0 6.796e-07 0 6.81e-07 0 6.811e-07 0 6.825e-07 0 6.826e-07 0 6.84e-07 0 6.841e-07 0 6.855e-07 0 6.856e-07 0 6.87e-07 0 6.87e-07 0 6.885e-07 0 6.885e-07 0 6.9e-07 0 6.9e-07 0 6.915e-07 0 6.915e-07 0 6.93e-07 0 6.93e-07 0 6.945e-07 0 6.945e-07 0 6.96e-07 0 6.96e-07 0 6.975e-07 0 6.975e-07 0 6.99e-07 0 6.991e-07 0 7.005e-07 0 7.006e-07 0 7.02e-07 0 7.021e-07 0 7.035e-07 0 7.036e-07 0 7.05e-07 0 7.051e-07 0 7.065e-07 0 7.066e-07 0 7.08e-07 0 7.081e-07 0 7.095e-07 0 7.096e-07 0 7.11e-07 0 7.11e-07 0 7.125e-07 0 7.125e-07 0 7.14e-07 0 7.14e-07 0 7.155e-07 0 7.155e-07 0 7.17e-07 0 7.17e-07 0 7.185e-07 0 7.185e-07 0 7.2e-07 0 7.2e-07 0 7.215e-07 0 7.215e-07 0 7.23e-07 0 7.231e-07 0 7.245e-07 0 7.246e-07 0 7.26e-07 0 7.261e-07 0 7.275e-07 0 7.276e-07 0 7.29e-07 0 7.291e-07 0 7.305e-07 0 7.306e-07 0 7.32e-07 0 7.321e-07 0 7.335e-07 0 7.335e-07 0 7.35e-07 0 7.35e-07 0 7.365e-07 0 7.365e-07 0 7.38e-07 0 7.38e-07 0 7.395e-07 0 7.395e-07 0 7.41e-07 0 7.41e-07 0 7.425e-07 0 7.425e-07 0 7.44e-07 0 7.44e-07 0 7.455e-07 0 7.456e-07 0 7.47e-07 0 7.471e-07 0 7.485e-07 0 7.486e-07 0 7.5e-07 0 7.501e-07 0 7.515e-07 0 7.516e-07 0 7.53e-07 0 7.531e-07 0 7.545e-07 0 7.546e-07 0 7.56e-07 0 7.561e-07 0 7.575e-07 0 7.575e-07 0 7.59e-07 0 7.59e-07 0 7.605e-07 0 7.605e-07 0 7.62e-07 0 7.62e-07 0 7.635e-07 0 7.635e-07 0 7.65e-07 0 7.65e-07 0 7.665e-07 0 7.665e-07 0)
VB3 B3 0 PWL(0 0 1.5e-09 0 1.55e-09 0 3e-09 0 3.05e-09 0 4.5e-09 0 4.55e-09 0 6e-09 0 6.05e-09 0 7.5e-09 0 7.55e-09 0 9e-09 0 9.05e-09 0 1.05e-08 0 1.055e-08 0 1.2e-08 0 1.205e-08 0 1.35e-08 0 1.355e-08 0 1.5e-08 0 1.505e-08 0 1.65e-08 0 1.655e-08 0 1.8e-08 0 1.805e-08 0 1.95e-08 0 1.955e-08 0 2.1e-08 0 2.105e-08 0 2.25e-08 0 2.255e-08 0 2.4e-08 0 2.405e-08 0 2.55e-08 0 2.555e-08 0 2.7e-08 0 2.705e-08 0 2.85e-08 0 2.855e-08 0 3e-08 0 3.005e-08 0 3.15e-08 0 3.155e-08 0 3.3e-08 0 3.305e-08 0 3.45e-08 0 3.455e-08 0 3.6e-08 0 3.605e-08 0 3.75e-08 0 3.755e-08 0 3.9e-08 0 3.905e-08 0 4.05e-08 0 4.055e-08 0 4.2e-08 0 4.205e-08 0 4.35e-08 0 4.355e-08 0 4.5e-08 0 4.505e-08 0 4.65e-08 0 4.655e-08 0 4.8e-08 0 4.805e-08 0 4.95e-08 0 4.955e-08 0 5.1e-08 0 5.105e-08 0 5.25e-08 0 5.255e-08 0 5.4e-08 0 5.405e-08 0 5.55e-08 0 5.555e-08 0 5.7e-08 0 5.705e-08 0 5.85e-08 0 5.855e-08 0 6e-08 0 6.005e-08 0 6.15e-08 0 6.155e-08 0 6.3e-08 0 6.305e-08 0 6.45e-08 0 6.455e-08 0 6.6e-08 0 6.605e-08 0 6.75e-08 0 6.755e-08 0 6.9e-08 0 6.905e-08 0 7.05e-08 0 7.055e-08 0 7.2e-08 0 7.205e-08 0 7.35e-08 0 7.355e-08 0 7.5e-08 0 7.505e-08 0 7.65e-08 0 7.655e-08 0 7.8e-08 0 7.805e-08 0 7.95e-08 0 7.955e-08 0 8.1e-08 0 8.105e-08 0 8.25e-08 0 8.255e-08 0 8.4e-08 0 8.405e-08 0 8.55e-08 0 8.555e-08 0 8.7e-08 0 8.705e-08 0 8.85e-08 0 8.855e-08 0 9e-08 0 9.005e-08 0 9.15e-08 0 9.155e-08 0 9.3e-08 0 9.305e-08 0 9.45e-08 0 9.455e-08 0 9.6e-08 0 9.605e-08 0 9.75e-08 0 9.755e-08 0 9.9e-08 0 9.905e-08 0 1.005e-07 0 1.005e-07 0 1.02e-07 0 1.021e-07 0 1.035e-07 0 1.035e-07 0 1.05e-07 0 1.051e-07 0 1.065e-07 0 1.065e-07 0 1.08e-07 0 1.081e-07 0 1.095e-07 0 1.095e-07 0 1.11e-07 0 1.111e-07 0 1.125e-07 0 1.125e-07 0 1.14e-07 0 1.141e-07 0 1.155e-07 0 1.155e-07 0 1.17e-07 0 1.171e-07 0 1.185e-07 0 1.185e-07 0 1.2e-07 0 1.2e-07 0 1.215e-07 0 1.215e-07 0 1.23e-07 0 1.231e-07 0 1.245e-07 0 1.246e-07 0 1.26e-07 0 1.26e-07 0 1.275e-07 0 1.276e-07 0 1.29e-07 0 1.291e-07 0 1.305e-07 0 1.306e-07 0 1.32e-07 0 1.32e-07 0 1.335e-07 0 1.336e-07 0 1.35e-07 0 1.351e-07 0 1.365e-07 0 1.366e-07 0 1.38e-07 0 1.38e-07 0 1.395e-07 0 1.396e-07 0 1.41e-07 0 1.411e-07 0 1.425e-07 0 1.426e-07 0 1.44e-07 0 1.44e-07 0 1.455e-07 0 1.456e-07 0 1.47e-07 0 1.471e-07 0 1.485e-07 0 1.485e-07 0 1.5e-07 0 1.5e-07 0 1.515e-07 0 1.516e-07 0 1.53e-07 0 1.531e-07 0 1.545e-07 0 1.545e-07 0 1.56e-07 0 1.56e-07 0 1.575e-07 0 1.576e-07 0 1.59e-07 0 1.591e-07 0 1.605e-07 0 1.605e-07 0 1.62e-07 0 1.62e-07 0 1.635e-07 0 1.636e-07 0 1.65e-07 0 1.651e-07 0 1.665e-07 0 1.665e-07 0 1.68e-07 0 1.68e-07 0 1.695e-07 0 1.696e-07 0 1.71e-07 0 1.711e-07 0 1.725e-07 0 1.725e-07 0 1.74e-07 0 1.741e-07 0 1.755e-07 0 1.756e-07 0 1.77e-07 0 1.771e-07 0 1.785e-07 0 1.785e-07 0 1.8e-07 0 1.801e-07 0 1.815e-07 0 1.816e-07 0 1.83e-07 0 1.831e-07 0 1.845e-07 0 1.845e-07 0 1.86e-07 0 1.861e-07 0 1.875e-07 0 1.876e-07 0 1.89e-07 0 1.891e-07 0 1.905e-07 0 1.905e-07 0 1.92e-07 0 1.921e-07 1.8 1.935e-07 1.8 1.936e-07 1.8 1.95e-07 1.8 1.95e-07 1.8 1.965e-07 1.8 1.965e-07 1.8 1.98e-07 1.8 1.981e-07 1.8 1.995e-07 1.8 1.996e-07 1.8 2.01e-07 1.8 2.01e-07 1.8 2.025e-07 1.8 2.025e-07 1.8 2.04e-07 1.8 2.041e-07 1.8 2.055e-07 1.8 2.056e-07 1.8 2.07e-07 1.8 2.07e-07 1.8 2.085e-07 1.8 2.085e-07 1.8 2.1e-07 1.8 2.101e-07 1.8 2.115e-07 1.8 2.116e-07 1.8 2.13e-07 1.8 2.13e-07 1.8 2.145e-07 1.8 2.145e-07 1.8 2.16e-07 1.8 2.161e-07 1.8 2.175e-07 1.8 2.176e-07 1.8 2.19e-07 1.8 2.19e-07 1.8 2.205e-07 1.8 2.205e-07 1.8 2.22e-07 1.8 2.221e-07 1.8 2.235e-07 1.8 2.236e-07 1.8 2.25e-07 1.8 2.25e-07 1.8 2.265e-07 1.8 2.266e-07 1.8 2.28e-07 1.8 2.281e-07 1.8 2.295e-07 1.8 2.296e-07 1.8 2.31e-07 1.8 2.31e-07 1.8 2.325e-07 1.8 2.326e-07 1.8 2.34e-07 1.8 2.341e-07 1.8 2.355e-07 1.8 2.356e-07 1.8 2.37e-07 1.8 2.37e-07 1.8 2.385e-07 1.8 2.386e-07 1.8 2.4e-07 1.8 2.4e-07 1.8 2.415e-07 1.8 2.415e-07 1.8 2.43e-07 1.8 2.43e-07 1.8 2.445e-07 1.8 2.446e-07 1.8 2.46e-07 1.8 2.461e-07 1.8 2.475e-07 1.8 2.476e-07 1.8 2.49e-07 1.8 2.491e-07 1.8 2.505e-07 1.8 2.505e-07 1.8 2.52e-07 1.8 2.52e-07 1.8 2.535e-07 1.8 2.535e-07 1.8 2.55e-07 1.8 2.55e-07 1.8 2.565e-07 1.8 2.566e-07 1.8 2.58e-07 1.8 2.581e-07 1.8 2.595e-07 1.8 2.596e-07 1.8 2.61e-07 1.8 2.611e-07 1.8 2.625e-07 1.8 2.625e-07 1.8 2.64e-07 1.8 2.64e-07 1.8 2.655e-07 1.8 2.655e-07 1.8 2.67e-07 1.8 2.67e-07 1.8 2.685e-07 1.8 2.686e-07 1.8 2.7e-07 1.8 2.701e-07 1.8 2.715e-07 1.8 2.716e-07 1.8 2.73e-07 1.8 2.731e-07 1.8 2.745e-07 1.8 2.745e-07 1.8 2.76e-07 1.8 2.76e-07 1.8 2.775e-07 1.8 2.775e-07 1.8 2.79e-07 1.8 2.791e-07 1.8 2.805e-07 1.8 2.806e-07 1.8 2.82e-07 1.8 2.821e-07 1.8 2.835e-07 1.8 2.836e-07 1.8 2.85e-07 1.8 2.851e-07 1.8 2.865e-07 1.8 2.865e-07 1.8 2.88e-07 1.8 2.88e-07 1.8 2.895e-07 1.8 2.895e-07 1.8 2.91e-07 1.8 2.911e-07 1.8 2.925e-07 1.8 2.926e-07 1.8 2.94e-07 1.8 2.941e-07 1.8 2.955e-07 1.8 2.956e-07 1.8 2.97e-07 1.8 2.97e-07 1.8 2.985e-07 1.8 2.985e-07 1.8 3e-07 1.8 3e-07 1.8 3.015e-07 1.8 3.015e-07 1.8 3.03e-07 1.8 3.031e-07 1.8 3.045e-07 1.8 3.046e-07 1.8 3.06e-07 1.8 3.061e-07 1.8 3.075e-07 1.8 3.076e-07 1.8 3.09e-07 1.8 3.09e-07 1.8 3.105e-07 1.8 3.105e-07 1.8 3.12e-07 1.8 3.12e-07 1.8 3.135e-07 1.8 3.135e-07 1.8 3.15e-07 1.8 3.151e-07 1.8 3.165e-07 1.8 3.166e-07 1.8 3.18e-07 1.8 3.181e-07 1.8 3.195e-07 1.8 3.196e-07 1.8 3.21e-07 1.8 3.21e-07 1.8 3.225e-07 1.8 3.225e-07 1.8 3.24e-07 1.8 3.24e-07 1.8 3.255e-07 1.8 3.256e-07 1.8 3.27e-07 1.8 3.271e-07 1.8 3.285e-07 1.8 3.286e-07 1.8 3.3e-07 1.8 3.301e-07 1.8 3.315e-07 1.8 3.316e-07 1.8 3.33e-07 1.8 3.33e-07 1.8 3.345e-07 1.8 3.345e-07 1.8 3.36e-07 1.8 3.36e-07 1.8 3.375e-07 1.8 3.376e-07 1.8 3.39e-07 1.8 3.391e-07 1.8 3.405e-07 1.8 3.406e-07 1.8 3.42e-07 1.8 3.421e-07 1.8 3.435e-07 1.8 3.435e-07 1.8 3.45e-07 1.8 3.45e-07 1.8 3.465e-07 1.8 3.465e-07 1.8 3.48e-07 1.8 3.48e-07 1.8 3.495e-07 1.8 3.496e-07 1.8 3.51e-07 1.8 3.511e-07 1.8 3.525e-07 1.8 3.526e-07 1.8 3.54e-07 1.8 3.541e-07 1.8 3.555e-07 1.8 3.555e-07 1.8 3.57e-07 1.8 3.57e-07 1.8 3.585e-07 1.8 3.585e-07 1.8 3.6e-07 1.8 3.6e-07 1.8 3.615e-07 1.8 3.616e-07 1.8 3.63e-07 1.8 3.631e-07 1.8 3.645e-07 1.8 3.646e-07 1.8 3.66e-07 1.8 3.661e-07 1.8 3.675e-07 1.8 3.675e-07 1.8 3.69e-07 1.8 3.69e-07 1.8 3.705e-07 1.8 3.705e-07 1.8 3.72e-07 1.8 3.72e-07 1.8 3.735e-07 1.8 3.736e-07 1.8 3.75e-07 1.8 3.751e-07 1.8 3.765e-07 1.8 3.766e-07 1.8 3.78e-07 1.8 3.781e-07 1.8 3.795e-07 1.8 3.795e-07 1.8 3.81e-07 1.8 3.81e-07 1.8 3.825e-07 1.8 3.825e-07 1.8 3.84e-07 1.8 3.841e-07 1.8 3.855e-07 1.8 3.856e-07 1.8 3.87e-07 1.8 3.871e-07 1.8 3.885e-07 1.8 3.886e-07 1.8 3.9e-07 1.8 3.9e-07 1.8 3.915e-07 1.8 3.915e-07 1.8 3.93e-07 1.8 3.93e-07 1.8 3.945e-07 1.8 3.945e-07 1.8 3.96e-07 1.8 3.961e-07 1.8 3.975e-07 1.8 3.976e-07 1.8 3.99e-07 1.8 3.991e-07 1.8 4.005e-07 1.8 4.006e-07 1.8 4.02e-07 1.8 4.02e-07 1.8 4.035e-07 1.8 4.035e-07 1.8 4.05e-07 1.8 4.05e-07 1.8 4.065e-07 1.8 4.065e-07 1.8 4.08e-07 1.8 4.081e-07 1.8 4.095e-07 1.8 4.096e-07 1.8 4.11e-07 1.8 4.111e-07 1.8 4.125e-07 1.8 4.126e-07 1.8 4.14e-07 1.8 4.14e-07 1.8 4.155e-07 1.8 4.155e-07 1.8 4.17e-07 1.8 4.17e-07 1.8 4.185e-07 1.8 4.185e-07 1.8 4.2e-07 1.8 4.201e-07 1.8 4.215e-07 1.8 4.216e-07 1.8 4.23e-07 1.8 4.231e-07 1.8 4.245e-07 1.8 4.246e-07 1.8 4.26e-07 1.8 4.26e-07 1.8 4.275e-07 1.8 4.275e-07 1.8 4.29e-07 1.8 4.29e-07 1.8 4.305e-07 1.8 4.306e-07 1.8 4.32e-07 1.8 4.321e-07 1.8 4.335e-07 1.8 4.336e-07 1.8 4.35e-07 1.8 4.351e-07 1.8 4.365e-07 1.8 4.365e-07 1.8 4.38e-07 1.8 4.38e-07 1.8 4.395e-07 1.8 4.395e-07 1.8 4.41e-07 1.8 4.41e-07 1.8 4.425e-07 1.8 4.426e-07 1.8 4.44e-07 1.8 4.441e-07 1.8 4.455e-07 1.8 4.456e-07 1.8 4.47e-07 1.8 4.471e-07 1.8 4.485e-07 1.8 4.485e-07 1.8 4.5e-07 1.8 4.5e-07 1.8 4.515e-07 1.8 4.515e-07 1.8 4.53e-07 1.8 4.53e-07 1.8 4.545e-07 1.8 4.546e-07 1.8 4.56e-07 1.8 4.561e-07 1.8 4.575e-07 1.8 4.576e-07 1.8 4.59e-07 1.8 4.591e-07 1.8 4.605e-07 1.8 4.605e-07 1.8 4.62e-07 1.8 4.62e-07 1.8 4.635e-07 1.8 4.635e-07 1.8 4.65e-07 1.8 4.65e-07 1.8 4.665e-07 1.8 4.666e-07 1.8 4.68e-07 1.8 4.681e-07 1.8 4.695e-07 1.8 4.696e-07 1.8 4.71e-07 1.8 4.711e-07 1.8 4.725e-07 1.8 4.725e-07 1.8 4.74e-07 1.8 4.74e-07 1.8 4.755e-07 1.8 4.755e-07 1.8 4.77e-07 1.8 4.771e-07 1.8 4.785e-07 1.8 4.785e-07 1.8 4.8e-07 1.8 4.8e-07 1.8 4.815e-07 1.8 4.815e-07 1.8 4.83e-07 1.8 4.83e-07 1.8 4.845e-07 1.8 4.845e-07 1.8 4.86e-07 1.8 4.86e-07 1.8 4.875e-07 1.8 4.875e-07 1.8 4.89e-07 1.8 4.891e-07 1.8 4.905e-07 1.8 4.906e-07 1.8 4.92e-07 1.8 4.921e-07 1.8 4.935e-07 1.8 4.936e-07 1.8 4.95e-07 1.8 4.951e-07 1.8 4.965e-07 1.8 4.966e-07 1.8 4.98e-07 1.8 4.981e-07 1.8 4.995e-07 1.8 4.996e-07 1.8 5.01e-07 1.8 5.01e-07 1.8 5.025e-07 1.8 5.025e-07 1.8 5.04e-07 1.8 5.04e-07 1.8 5.055e-07 1.8 5.055e-07 1.8 5.07e-07 1.8 5.07e-07 1.8 5.085e-07 1.8 5.085e-07 1.8 5.1e-07 1.8 5.1e-07 1.8 5.115e-07 1.8 5.115e-07 1.8 5.13e-07 1.8 5.131e-07 1.8 5.145e-07 1.8 5.146e-07 1.8 5.16e-07 1.8 5.161e-07 1.8 5.175e-07 1.8 5.176e-07 1.8 5.19e-07 1.8 5.191e-07 1.8 5.205e-07 1.8 5.206e-07 1.8 5.22e-07 1.8 5.221e-07 1.8 5.235e-07 1.8 5.236e-07 1.8 5.25e-07 1.8 5.25e-07 1.8 5.265e-07 1.8 5.265e-07 1.8 5.28e-07 1.8 5.28e-07 1.8 5.295e-07 1.8 5.295e-07 1.8 5.31e-07 1.8 5.31e-07 1.8 5.325e-07 1.8 5.325e-07 1.8 5.34e-07 1.8 5.34e-07 1.8 5.355e-07 1.8 5.356e-07 1.8 5.37e-07 1.8 5.371e-07 1.8 5.385e-07 1.8 5.386e-07 1.8 5.4e-07 1.8 5.401e-07 1.8 5.415e-07 1.8 5.416e-07 1.8 5.43e-07 1.8 5.431e-07 1.8 5.445e-07 1.8 5.446e-07 1.8 5.46e-07 1.8 5.461e-07 1.8 5.475e-07 1.8 5.475e-07 1.8 5.49e-07 1.8 5.49e-07 1.8 5.505e-07 1.8 5.505e-07 1.8 5.52e-07 1.8 5.52e-07 1.8 5.535e-07 1.8 5.535e-07 1.8 5.55e-07 1.8 5.55e-07 1.8 5.565e-07 1.8 5.565e-07 1.8 5.58e-07 1.8 5.58e-07 1.8 5.595e-07 1.8 5.596e-07 1.8 5.61e-07 1.8 5.611e-07 1.8 5.625e-07 1.8 5.626e-07 1.8 5.64e-07 1.8 5.641e-07 1.8 5.655e-07 1.8 5.656e-07 1.8 5.67e-07 1.8 5.671e-07 1.8 5.685e-07 1.8 5.686e-07 1.8 5.7e-07 1.8 5.701e-07 1.8 5.715e-07 1.8 5.715e-07 1.8 5.73e-07 1.8 5.73e-07 1.8 5.745e-07 1.8 5.745e-07 1.8 5.76e-07 1.8 5.76e-07 0 5.775e-07 0 5.775e-07 0 5.79e-07 0 5.79e-07 0 5.805e-07 0 5.805e-07 0 5.82e-07 0 5.821e-07 0 5.835e-07 0 5.836e-07 0 5.85e-07 0 5.851e-07 0 5.865e-07 0 5.866e-07 0 5.88e-07 0 5.881e-07 0 5.895e-07 0 5.896e-07 0 5.91e-07 0 5.911e-07 0 5.925e-07 0 5.926e-07 0 5.94e-07 0 5.94e-07 0 5.955e-07 0 5.955e-07 0 5.97e-07 0 5.97e-07 0 5.985e-07 0 5.985e-07 0 6e-07 0 6e-07 0 6.015e-07 0 6.015e-07 0 6.03e-07 0 6.03e-07 0 6.045e-07 0 6.045e-07 0 6.06e-07 0 6.061e-07 0 6.075e-07 0 6.076e-07 0 6.09e-07 0 6.091e-07 0 6.105e-07 0 6.106e-07 0 6.12e-07 0 6.121e-07 0 6.135e-07 0 6.136e-07 0 6.15e-07 0 6.151e-07 0 6.165e-07 0 6.166e-07 0 6.18e-07 0 6.18e-07 0 6.195e-07 0 6.195e-07 0 6.21e-07 0 6.21e-07 0 6.225e-07 0 6.225e-07 0 6.24e-07 0 6.24e-07 0 6.255e-07 0 6.255e-07 0 6.27e-07 0 6.27e-07 0 6.285e-07 0 6.286e-07 0 6.3e-07 0 6.301e-07 0 6.315e-07 0 6.316e-07 0 6.33e-07 0 6.331e-07 0 6.345e-07 0 6.346e-07 0 6.36e-07 0 6.361e-07 0 6.375e-07 0 6.376e-07 0 6.39e-07 0 6.391e-07 0 6.405e-07 0 6.405e-07 0 6.42e-07 0 6.42e-07 0 6.435e-07 0 6.435e-07 0 6.45e-07 0 6.45e-07 0 6.465e-07 0 6.465e-07 0 6.48e-07 0 6.48e-07 0 6.495e-07 0 6.495e-07 0 6.51e-07 0 6.51e-07 0 6.525e-07 0 6.526e-07 0 6.54e-07 0 6.541e-07 0 6.555e-07 0 6.556e-07 0 6.57e-07 0 6.571e-07 0 6.585e-07 0 6.586e-07 0 6.6e-07 0 6.601e-07 0 6.615e-07 0 6.616e-07 0 6.63e-07 0 6.631e-07 0 6.645e-07 0 6.645e-07 0 6.66e-07 0 6.66e-07 0 6.675e-07 0 6.675e-07 0 6.69e-07 0 6.69e-07 0 6.705e-07 0 6.705e-07 0 6.72e-07 0 6.72e-07 0 6.735e-07 0 6.735e-07 0 6.75e-07 0 6.75e-07 0 6.765e-07 0 6.766e-07 0 6.78e-07 0 6.781e-07 0 6.795e-07 0 6.796e-07 0 6.81e-07 0 6.811e-07 0 6.825e-07 0 6.826e-07 0 6.84e-07 0 6.841e-07 0 6.855e-07 0 6.856e-07 0 6.87e-07 0 6.87e-07 0 6.885e-07 0 6.885e-07 0 6.9e-07 0 6.9e-07 0 6.915e-07 0 6.915e-07 0 6.93e-07 0 6.93e-07 0 6.945e-07 0 6.945e-07 0 6.96e-07 0 6.96e-07 0 6.975e-07 0 6.975e-07 0 6.99e-07 0 6.991e-07 0 7.005e-07 0 7.006e-07 0 7.02e-07 0 7.021e-07 0 7.035e-07 0 7.036e-07 0 7.05e-07 0 7.051e-07 0 7.065e-07 0 7.066e-07 0 7.08e-07 0 7.081e-07 0 7.095e-07 0 7.096e-07 0 7.11e-07 0 7.11e-07 0 7.125e-07 0 7.125e-07 0 7.14e-07 0 7.14e-07 0 7.155e-07 0 7.155e-07 0 7.17e-07 0 7.17e-07 0 7.185e-07 0 7.185e-07 0 7.2e-07 0 7.2e-07 0 7.215e-07 0 7.215e-07 0 7.23e-07 0 7.231e-07 0 7.245e-07 0 7.246e-07 0 7.26e-07 0 7.261e-07 0 7.275e-07 0 7.276e-07 0 7.29e-07 0 7.291e-07 0 7.305e-07 0 7.306e-07 0 7.32e-07 0 7.321e-07 0 7.335e-07 0 7.335e-07 0 7.35e-07 0 7.35e-07 0 7.365e-07 0 7.365e-07 0 7.38e-07 0 7.38e-07 0 7.395e-07 0 7.395e-07 0 7.41e-07 0 7.41e-07 0 7.425e-07 0 7.425e-07 0 7.44e-07 0 7.44e-07 0 7.455e-07 0 7.456e-07 0 7.47e-07 0 7.471e-07 0 7.485e-07 0 7.486e-07 0 7.5e-07 0 7.501e-07 0 7.515e-07 0 7.516e-07 0 7.53e-07 0 7.531e-07 0 7.545e-07 0 7.546e-07 0 7.56e-07 0 7.561e-07 0 7.575e-07 0 7.575e-07 0 7.59e-07 0 7.59e-07 0 7.605e-07 0 7.605e-07 0 7.62e-07 0 7.62e-07 0 7.635e-07 0 7.635e-07 0 7.65e-07 0 7.65e-07 0 7.665e-07 0 7.665e-07 0)
VCin Cin 0 PWL(0 0 1.5e-09 0 1.55e-09 0 3e-09 0 3.05e-09 0 4.5e-09 0 4.55e-09 0 6e-09 0 6.05e-09 0 7.5e-09 0 7.55e-09 0 9e-09 0 9.05e-09 0 1.05e-08 0 1.055e-08 0 1.2e-08 0 1.205e-08 0 1.35e-08 0 1.355e-08 0 1.5e-08 0 1.505e-08 0 1.65e-08 0 1.655e-08 0 1.8e-08 0 1.805e-08 0 1.95e-08 0 1.955e-08 0 2.1e-08 0 2.105e-08 0 2.25e-08 0 2.255e-08 0 2.4e-08 0 2.405e-08 0 2.55e-08 0 2.555e-08 0 2.7e-08 0 2.705e-08 0 2.85e-08 0 2.855e-08 0 3e-08 0 3.005e-08 0 3.15e-08 0 3.155e-08 0 3.3e-08 0 3.305e-08 0 3.45e-08 0 3.455e-08 0 3.6e-08 0 3.605e-08 0 3.75e-08 0 3.755e-08 0 3.9e-08 0 3.905e-08 0 4.05e-08 0 4.055e-08 0 4.2e-08 0 4.205e-08 0 4.35e-08 0 4.355e-08 0 4.5e-08 0 4.505e-08 0 4.65e-08 0 4.655e-08 0 4.8e-08 0 4.805e-08 0 4.95e-08 0 4.955e-08 0 5.1e-08 0 5.105e-08 0 5.25e-08 0 5.255e-08 0 5.4e-08 0 5.405e-08 0 5.55e-08 0 5.555e-08 0 5.7e-08 0 5.705e-08 0 5.85e-08 0 5.855e-08 0 6e-08 0 6.005e-08 0 6.15e-08 0 6.155e-08 0 6.3e-08 0 6.305e-08 0 6.45e-08 0 6.455e-08 0 6.6e-08 0 6.605e-08 0 6.75e-08 0 6.755e-08 0 6.9e-08 0 6.905e-08 0 7.05e-08 0 7.055e-08 0 7.2e-08 0 7.205e-08 0 7.35e-08 0 7.355e-08 0 7.5e-08 0 7.505e-08 0 7.65e-08 0 7.655e-08 0 7.8e-08 0 7.805e-08 0 7.95e-08 0 7.955e-08 0 8.1e-08 0 8.105e-08 0 8.25e-08 0 8.255e-08 0 8.4e-08 0 8.405e-08 0 8.55e-08 0 8.555e-08 0 8.7e-08 0 8.705e-08 0 8.85e-08 0 8.855e-08 0 9e-08 0 9.005e-08 0 9.15e-08 0 9.155e-08 0 9.3e-08 0 9.305e-08 0 9.45e-08 0 9.455e-08 0 9.6e-08 0 9.605e-08 0 9.75e-08 0 9.755e-08 0 9.9e-08 0 9.905e-08 0 1.005e-07 0 1.005e-07 0 1.02e-07 0 1.021e-07 0 1.035e-07 0 1.035e-07 0 1.05e-07 0 1.051e-07 0 1.065e-07 0 1.065e-07 0 1.08e-07 0 1.081e-07 0 1.095e-07 0 1.095e-07 0 1.11e-07 0 1.111e-07 0 1.125e-07 0 1.125e-07 0 1.14e-07 0 1.141e-07 0 1.155e-07 0 1.155e-07 0 1.17e-07 0 1.171e-07 0 1.185e-07 0 1.185e-07 0 1.2e-07 0 1.2e-07 0 1.215e-07 0 1.215e-07 0 1.23e-07 0 1.231e-07 0 1.245e-07 0 1.246e-07 0 1.26e-07 0 1.26e-07 0 1.275e-07 0 1.276e-07 0 1.29e-07 0 1.291e-07 0 1.305e-07 0 1.306e-07 0 1.32e-07 0 1.32e-07 0 1.335e-07 0 1.336e-07 0 1.35e-07 0 1.351e-07 0 1.365e-07 0 1.366e-07 0 1.38e-07 0 1.38e-07 0 1.395e-07 0 1.396e-07 0 1.41e-07 0 1.411e-07 0 1.425e-07 0 1.426e-07 0 1.44e-07 0 1.44e-07 0 1.455e-07 0 1.456e-07 0 1.47e-07 0 1.471e-07 0 1.485e-07 0 1.485e-07 0 1.5e-07 0 1.5e-07 0 1.515e-07 0 1.516e-07 0 1.53e-07 0 1.531e-07 0 1.545e-07 0 1.545e-07 0 1.56e-07 0 1.56e-07 0 1.575e-07 0 1.576e-07 0 1.59e-07 0 1.591e-07 0 1.605e-07 0 1.605e-07 0 1.62e-07 0 1.62e-07 0 1.635e-07 0 1.636e-07 0 1.65e-07 0 1.651e-07 0 1.665e-07 0 1.665e-07 0 1.68e-07 0 1.68e-07 0 1.695e-07 0 1.696e-07 0 1.71e-07 0 1.711e-07 0 1.725e-07 0 1.725e-07 0 1.74e-07 0 1.741e-07 0 1.755e-07 0 1.756e-07 0 1.77e-07 0 1.771e-07 0 1.785e-07 0 1.785e-07 0 1.8e-07 0 1.801e-07 0 1.815e-07 0 1.816e-07 0 1.83e-07 0 1.831e-07 0 1.845e-07 0 1.845e-07 0 1.86e-07 0 1.861e-07 0 1.875e-07 0 1.876e-07 0 1.89e-07 0 1.891e-07 0 1.905e-07 0 1.905e-07 0 1.92e-07 0 1.921e-07 0 1.935e-07 0 1.936e-07 0 1.95e-07 0 1.95e-07 0 1.965e-07 0 1.965e-07 0 1.98e-07 0 1.981e-07 0 1.995e-07 0 1.996e-07 0 2.01e-07 0 2.01e-07 0 2.025e-07 0 2.025e-07 0 2.04e-07 0 2.041e-07 0 2.055e-07 0 2.056e-07 0 2.07e-07 0 2.07e-07 0 2.085e-07 0 2.085e-07 0 2.1e-07 0 2.101e-07 0 2.115e-07 0 2.116e-07 0 2.13e-07 0 2.13e-07 0 2.145e-07 0 2.145e-07 0 2.16e-07 0 2.161e-07 0 2.175e-07 0 2.176e-07 0 2.19e-07 0 2.19e-07 0 2.205e-07 0 2.205e-07 0 2.22e-07 0 2.221e-07 0 2.235e-07 0 2.236e-07 0 2.25e-07 0 2.25e-07 0 2.265e-07 0 2.266e-07 0 2.28e-07 0 2.281e-07 0 2.295e-07 0 2.296e-07 0 2.31e-07 0 2.31e-07 0 2.325e-07 0 2.326e-07 0 2.34e-07 0 2.341e-07 0 2.355e-07 0 2.356e-07 0 2.37e-07 0 2.37e-07 0 2.385e-07 0 2.386e-07 0 2.4e-07 0 2.4e-07 0 2.415e-07 0 2.415e-07 0 2.43e-07 0 2.43e-07 0 2.445e-07 0 2.446e-07 0 2.46e-07 0 2.461e-07 0 2.475e-07 0 2.476e-07 0 2.49e-07 0 2.491e-07 0 2.505e-07 0 2.505e-07 0 2.52e-07 0 2.52e-07 0 2.535e-07 0 2.535e-07 0 2.55e-07 0 2.55e-07 0 2.565e-07 0 2.566e-07 0 2.58e-07 0 2.581e-07 0 2.595e-07 0 2.596e-07 0 2.61e-07 0 2.611e-07 0 2.625e-07 0 2.625e-07 0 2.64e-07 0 2.64e-07 0 2.655e-07 0 2.655e-07 0 2.67e-07 0 2.67e-07 0 2.685e-07 0 2.686e-07 0 2.7e-07 0 2.701e-07 0 2.715e-07 0 2.716e-07 0 2.73e-07 0 2.731e-07 0 2.745e-07 0 2.745e-07 0 2.76e-07 0 2.76e-07 0 2.775e-07 0 2.775e-07 0 2.79e-07 0 2.791e-07 0 2.805e-07 0 2.806e-07 0 2.82e-07 0 2.821e-07 0 2.835e-07 0 2.836e-07 0 2.85e-07 0 2.851e-07 0 2.865e-07 0 2.865e-07 0 2.88e-07 0 2.88e-07 0 2.895e-07 0 2.895e-07 0 2.91e-07 0 2.911e-07 0 2.925e-07 0 2.926e-07 0 2.94e-07 0 2.941e-07 0 2.955e-07 0 2.956e-07 0 2.97e-07 0 2.97e-07 0 2.985e-07 0 2.985e-07 0 3e-07 0 3e-07 0 3.015e-07 0 3.015e-07 0 3.03e-07 0 3.031e-07 0 3.045e-07 0 3.046e-07 0 3.06e-07 0 3.061e-07 0 3.075e-07 0 3.076e-07 0 3.09e-07 0 3.09e-07 0 3.105e-07 0 3.105e-07 0 3.12e-07 0 3.12e-07 0 3.135e-07 0 3.135e-07 0 3.15e-07 0 3.151e-07 0 3.165e-07 0 3.166e-07 0 3.18e-07 0 3.181e-07 0 3.195e-07 0 3.196e-07 0 3.21e-07 0 3.21e-07 0 3.225e-07 0 3.225e-07 0 3.24e-07 0 3.24e-07 0 3.255e-07 0 3.256e-07 0 3.27e-07 0 3.271e-07 0 3.285e-07 0 3.286e-07 0 3.3e-07 0 3.301e-07 0 3.315e-07 0 3.316e-07 0 3.33e-07 0 3.33e-07 0 3.345e-07 0 3.345e-07 0 3.36e-07 0 3.36e-07 0 3.375e-07 0 3.376e-07 0 3.39e-07 0 3.391e-07 0 3.405e-07 0 3.406e-07 0 3.42e-07 0 3.421e-07 0 3.435e-07 0 3.435e-07 0 3.45e-07 0 3.45e-07 0 3.465e-07 0 3.465e-07 0 3.48e-07 0 3.48e-07 0 3.495e-07 0 3.496e-07 0 3.51e-07 0 3.511e-07 0 3.525e-07 0 3.526e-07 0 3.54e-07 0 3.541e-07 0 3.555e-07 0 3.555e-07 0 3.57e-07 0 3.57e-07 0 3.585e-07 0 3.585e-07 0 3.6e-07 0 3.6e-07 0 3.615e-07 0 3.616e-07 0 3.63e-07 0 3.631e-07 0 3.645e-07 0 3.646e-07 0 3.66e-07 0 3.661e-07 0 3.675e-07 0 3.675e-07 0 3.69e-07 0 3.69e-07 0 3.705e-07 0 3.705e-07 0 3.72e-07 0 3.72e-07 0 3.735e-07 0 3.736e-07 0 3.75e-07 0 3.751e-07 0 3.765e-07 0 3.766e-07 0 3.78e-07 0 3.781e-07 0 3.795e-07 0 3.795e-07 0 3.81e-07 0 3.81e-07 0 3.825e-07 0 3.825e-07 0 3.84e-07 0 3.841e-07 1.8 3.855e-07 1.8 3.856e-07 1.8 3.87e-07 1.8 3.871e-07 1.8 3.885e-07 1.8 3.886e-07 1.8 3.9e-07 1.8 3.9e-07 1.8 3.915e-07 1.8 3.915e-07 1.8 3.93e-07 1.8 3.93e-07 1.8 3.945e-07 1.8 3.945e-07 1.8 3.96e-07 1.8 3.961e-07 1.8 3.975e-07 1.8 3.976e-07 1.8 3.99e-07 1.8 3.991e-07 1.8 4.005e-07 1.8 4.006e-07 1.8 4.02e-07 1.8 4.02e-07 1.8 4.035e-07 1.8 4.035e-07 1.8 4.05e-07 1.8 4.05e-07 1.8 4.065e-07 1.8 4.065e-07 1.8 4.08e-07 1.8 4.081e-07 1.8 4.095e-07 1.8 4.096e-07 1.8 4.11e-07 1.8 4.111e-07 1.8 4.125e-07 1.8 4.126e-07 1.8 4.14e-07 1.8 4.14e-07 1.8 4.155e-07 1.8 4.155e-07 1.8 4.17e-07 1.8 4.17e-07 1.8 4.185e-07 1.8 4.185e-07 1.8 4.2e-07 1.8 4.201e-07 1.8 4.215e-07 1.8 4.216e-07 1.8 4.23e-07 1.8 4.231e-07 1.8 4.245e-07 1.8 4.246e-07 1.8 4.26e-07 1.8 4.26e-07 1.8 4.275e-07 1.8 4.275e-07 1.8 4.29e-07 1.8 4.29e-07 1.8 4.305e-07 1.8 4.306e-07 1.8 4.32e-07 1.8 4.321e-07 1.8 4.335e-07 1.8 4.336e-07 1.8 4.35e-07 1.8 4.351e-07 1.8 4.365e-07 1.8 4.365e-07 1.8 4.38e-07 1.8 4.38e-07 1.8 4.395e-07 1.8 4.395e-07 1.8 4.41e-07 1.8 4.41e-07 1.8 4.425e-07 1.8 4.426e-07 1.8 4.44e-07 1.8 4.441e-07 1.8 4.455e-07 1.8 4.456e-07 1.8 4.47e-07 1.8 4.471e-07 1.8 4.485e-07 1.8 4.485e-07 1.8 4.5e-07 1.8 4.5e-07 1.8 4.515e-07 1.8 4.515e-07 1.8 4.53e-07 1.8 4.53e-07 1.8 4.545e-07 1.8 4.546e-07 1.8 4.56e-07 1.8 4.561e-07 1.8 4.575e-07 1.8 4.576e-07 1.8 4.59e-07 1.8 4.591e-07 1.8 4.605e-07 1.8 4.605e-07 1.8 4.62e-07 1.8 4.62e-07 1.8 4.635e-07 1.8 4.635e-07 1.8 4.65e-07 1.8 4.65e-07 1.8 4.665e-07 1.8 4.666e-07 1.8 4.68e-07 1.8 4.681e-07 1.8 4.695e-07 1.8 4.696e-07 1.8 4.71e-07 1.8 4.711e-07 1.8 4.725e-07 1.8 4.725e-07 1.8 4.74e-07 1.8 4.74e-07 1.8 4.755e-07 1.8 4.755e-07 1.8 4.77e-07 1.8 4.771e-07 1.8 4.785e-07 1.8 4.785e-07 1.8 4.8e-07 1.8 4.8e-07 1.8 4.815e-07 1.8 4.815e-07 1.8 4.83e-07 1.8 4.83e-07 1.8 4.845e-07 1.8 4.845e-07 1.8 4.86e-07 1.8 4.86e-07 1.8 4.875e-07 1.8 4.875e-07 1.8 4.89e-07 1.8 4.891e-07 1.8 4.905e-07 1.8 4.906e-07 1.8 4.92e-07 1.8 4.921e-07 1.8 4.935e-07 1.8 4.936e-07 1.8 4.95e-07 1.8 4.951e-07 1.8 4.965e-07 1.8 4.966e-07 1.8 4.98e-07 1.8 4.981e-07 1.8 4.995e-07 1.8 4.996e-07 1.8 5.01e-07 1.8 5.01e-07 1.8 5.025e-07 1.8 5.025e-07 1.8 5.04e-07 1.8 5.04e-07 1.8 5.055e-07 1.8 5.055e-07 1.8 5.07e-07 1.8 5.07e-07 1.8 5.085e-07 1.8 5.085e-07 1.8 5.1e-07 1.8 5.1e-07 1.8 5.115e-07 1.8 5.115e-07 1.8 5.13e-07 1.8 5.131e-07 1.8 5.145e-07 1.8 5.146e-07 1.8 5.16e-07 1.8 5.161e-07 1.8 5.175e-07 1.8 5.176e-07 1.8 5.19e-07 1.8 5.191e-07 1.8 5.205e-07 1.8 5.206e-07 1.8 5.22e-07 1.8 5.221e-07 1.8 5.235e-07 1.8 5.236e-07 1.8 5.25e-07 1.8 5.25e-07 1.8 5.265e-07 1.8 5.265e-07 1.8 5.28e-07 1.8 5.28e-07 1.8 5.295e-07 1.8 5.295e-07 1.8 5.31e-07 1.8 5.31e-07 1.8 5.325e-07 1.8 5.325e-07 1.8 5.34e-07 1.8 5.34e-07 1.8 5.355e-07 1.8 5.356e-07 1.8 5.37e-07 1.8 5.371e-07 1.8 5.385e-07 1.8 5.386e-07 1.8 5.4e-07 1.8 5.401e-07 1.8 5.415e-07 1.8 5.416e-07 1.8 5.43e-07 1.8 5.431e-07 1.8 5.445e-07 1.8 5.446e-07 1.8 5.46e-07 1.8 5.461e-07 1.8 5.475e-07 1.8 5.475e-07 1.8 5.49e-07 1.8 5.49e-07 1.8 5.505e-07 1.8 5.505e-07 1.8 5.52e-07 1.8 5.52e-07 1.8 5.535e-07 1.8 5.535e-07 1.8 5.55e-07 1.8 5.55e-07 1.8 5.565e-07 1.8 5.565e-07 1.8 5.58e-07 1.8 5.58e-07 1.8 5.595e-07 1.8 5.596e-07 1.8 5.61e-07 1.8 5.611e-07 1.8 5.625e-07 1.8 5.626e-07 1.8 5.64e-07 1.8 5.641e-07 1.8 5.655e-07 1.8 5.656e-07 1.8 5.67e-07 1.8 5.671e-07 1.8 5.685e-07 1.8 5.686e-07 1.8 5.7e-07 1.8 5.701e-07 1.8 5.715e-07 1.8 5.715e-07 1.8 5.73e-07 1.8 5.73e-07 1.8 5.745e-07 1.8 5.745e-07 1.8 5.76e-07 1.8 5.76e-07 1.8 5.775e-07 1.8 5.775e-07 1.8 5.79e-07 1.8 5.79e-07 1.8 5.805e-07 1.8 5.805e-07 1.8 5.82e-07 1.8 5.821e-07 1.8 5.835e-07 1.8 5.836e-07 1.8 5.85e-07 1.8 5.851e-07 1.8 5.865e-07 1.8 5.866e-07 1.8 5.88e-07 1.8 5.881e-07 1.8 5.895e-07 1.8 5.896e-07 1.8 5.91e-07 1.8 5.911e-07 1.8 5.925e-07 1.8 5.926e-07 1.8 5.94e-07 1.8 5.94e-07 1.8 5.955e-07 1.8 5.955e-07 1.8 5.97e-07 1.8 5.97e-07 1.8 5.985e-07 1.8 5.985e-07 1.8 6e-07 1.8 6e-07 1.8 6.015e-07 1.8 6.015e-07 1.8 6.03e-07 1.8 6.03e-07 1.8 6.045e-07 1.8 6.045e-07 1.8 6.06e-07 1.8 6.061e-07 1.8 6.075e-07 1.8 6.076e-07 1.8 6.09e-07 1.8 6.091e-07 1.8 6.105e-07 1.8 6.106e-07 1.8 6.12e-07 1.8 6.121e-07 1.8 6.135e-07 1.8 6.136e-07 1.8 6.15e-07 1.8 6.151e-07 1.8 6.165e-07 1.8 6.166e-07 1.8 6.18e-07 1.8 6.18e-07 1.8 6.195e-07 1.8 6.195e-07 1.8 6.21e-07 1.8 6.21e-07 1.8 6.225e-07 1.8 6.225e-07 1.8 6.24e-07 1.8 6.24e-07 1.8 6.255e-07 1.8 6.255e-07 1.8 6.27e-07 1.8 6.27e-07 1.8 6.285e-07 1.8 6.286e-07 1.8 6.3e-07 1.8 6.301e-07 1.8 6.315e-07 1.8 6.316e-07 1.8 6.33e-07 1.8 6.331e-07 1.8 6.345e-07 1.8 6.346e-07 1.8 6.36e-07 1.8 6.361e-07 1.8 6.375e-07 1.8 6.376e-07 1.8 6.39e-07 1.8 6.391e-07 1.8 6.405e-07 1.8 6.405e-07 1.8 6.42e-07 1.8 6.42e-07 1.8 6.435e-07 1.8 6.435e-07 1.8 6.45e-07 1.8 6.45e-07 1.8 6.465e-07 1.8 6.465e-07 1.8 6.48e-07 1.8 6.48e-07 1.8 6.495e-07 1.8 6.495e-07 1.8 6.51e-07 1.8 6.51e-07 1.8 6.525e-07 1.8 6.526e-07 1.8 6.54e-07 1.8 6.541e-07 1.8 6.555e-07 1.8 6.556e-07 1.8 6.57e-07 1.8 6.571e-07 1.8 6.585e-07 1.8 6.586e-07 1.8 6.6e-07 1.8 6.601e-07 1.8 6.615e-07 1.8 6.616e-07 1.8 6.63e-07 1.8 6.631e-07 1.8 6.645e-07 1.8 6.645e-07 1.8 6.66e-07 1.8 6.66e-07 1.8 6.675e-07 1.8 6.675e-07 1.8 6.69e-07 1.8 6.69e-07 1.8 6.705e-07 1.8 6.705e-07 1.8 6.72e-07 1.8 6.72e-07 1.8 6.735e-07 1.8 6.735e-07 1.8 6.75e-07 1.8 6.75e-07 1.8 6.765e-07 1.8 6.766e-07 1.8 6.78e-07 1.8 6.781e-07 1.8 6.795e-07 1.8 6.796e-07 1.8 6.81e-07 1.8 6.811e-07 1.8 6.825e-07 1.8 6.826e-07 1.8 6.84e-07 1.8 6.841e-07 1.8 6.855e-07 1.8 6.856e-07 1.8 6.87e-07 1.8 6.87e-07 1.8 6.885e-07 1.8 6.885e-07 1.8 6.9e-07 1.8 6.9e-07 1.8 6.915e-07 1.8 6.915e-07 1.8 6.93e-07 1.8 6.93e-07 1.8 6.945e-07 1.8 6.945e-07 1.8 6.96e-07 1.8 6.96e-07 1.8 6.975e-07 1.8 6.975e-07 1.8 6.99e-07 1.8 6.991e-07 1.8 7.005e-07 1.8 7.006e-07 1.8 7.02e-07 1.8 7.021e-07 1.8 7.035e-07 1.8 7.036e-07 1.8 7.05e-07 1.8 7.051e-07 1.8 7.065e-07 1.8 7.066e-07 1.8 7.08e-07 1.8 7.081e-07 1.8 7.095e-07 1.8 7.096e-07 1.8 7.11e-07 1.8 7.11e-07 1.8 7.125e-07 1.8 7.125e-07 1.8 7.14e-07 1.8 7.14e-07 1.8 7.155e-07 1.8 7.155e-07 1.8 7.17e-07 1.8 7.17e-07 1.8 7.185e-07 1.8 7.185e-07 1.8 7.2e-07 1.8 7.2e-07 1.8 7.215e-07 1.8 7.215e-07 1.8 7.23e-07 1.8 7.231e-07 1.8 7.245e-07 1.8 7.246e-07 1.8 7.26e-07 1.8 7.261e-07 1.8 7.275e-07 1.8 7.276e-07 1.8 7.29e-07 1.8 7.291e-07 1.8 7.305e-07 1.8 7.306e-07 1.8 7.32e-07 1.8 7.321e-07 1.8 7.335e-07 1.8 7.335e-07 1.8 7.35e-07 1.8 7.35e-07 1.8 7.365e-07 1.8 7.365e-07 1.8 7.38e-07 1.8 7.38e-07 1.8 7.395e-07 1.8 7.395e-07 1.8 7.41e-07 1.8 7.41e-07 1.8 7.425e-07 1.8 7.425e-07 1.8 7.44e-07 1.8 7.44e-07 1.8 7.455e-07 1.8 7.456e-07 1.8 7.47e-07 1.8 7.471e-07 1.8 7.485e-07 1.8 7.486e-07 1.8 7.5e-07 1.8 7.501e-07 1.8 7.515e-07 1.8 7.516e-07 1.8 7.53e-07 1.8 7.531e-07 1.8 7.545e-07 1.8 7.546e-07 1.8 7.56e-07 1.8 7.561e-07 1.8 7.575e-07 1.8 7.575e-07 1.8 7.59e-07 1.8 7.59e-07 1.8 7.605e-07 1.8 7.605e-07 1.8 7.62e-07 1.8 7.62e-07 1.8 7.635e-07 1.8 7.635e-07 1.8 7.65e-07 1.8 7.65e-07 1.8 7.665e-07 1.8 7.665e-07 1.8)
CS0 S0 0 1e-14
CS1 S1 0 1e-14
CS2 S2 0 1e-14
CS3 S3 0 1e-14
CCout Cout 0 1e-14
.option method=gear
.control
tran 5p 7.68e-07
wrdata /home/ellis/EG-LOGIC/examples/adder4/sky130A/ADD4_sim.dat v(S0) v(S1) v(S2) v(S3) v(Cout)
quit
.endc
.end
