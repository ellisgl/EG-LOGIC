* NGSPICE file created from AND.ext - technology: gf180mcuD

.subckt AND A B Y VDD VSS
X0 VDD A a_323_n286# VDD pfet_03v3 ad=0.53p pd=2.53u as=0.9p ps=4.9u w=2u l=0.28u
X1 a_469_n286# A a_323_n286# VSS nfet_03v3 ad=0.265p pd=1.53u as=0.45p ps=2.9u w=1u l=0.28u
X2 Y a_323_n286# VSS VSS nfet_03v3 ad=0.625p pd=3.25u as=0.625p ps=3.25u w=1u l=0.28u
X3 VSS B a_469_n286# VSS nfet_03v3 ad=0.45p pd=2.9u as=0.265p ps=1.53u w=1u l=0.28u
X4 Y a_323_n286# VDD VDD pfet_03v3 ad=1.25p pd=5.25u as=1.25p ps=5.25u w=2u l=0.28u
X5 a_323_n286# B VDD VDD pfet_03v3 ad=0.9p pd=4.9u as=0.53p ps=2.53u w=2u l=0.28u
C0 a_323_n286# a_469_n286# 0.01435f
C1 a_323_n286# VDD 1.15177f
C2 a_323_n286# A 0.06277f
C3 a_323_n286# B 0.07031f
C4 a_323_n286# Y 0.12848f
C5 a_469_n286# VDD 0.00121f
C6 a_469_n286# Y 0
C7 VDD A 0.58621f
C8 VDD B 0.12259f
C9 VDD Y 0.55505f
C10 A B 0.05053f
C11 A Y 0
C12 B Y 0
C13 Y VSS 0.64505f
C14 B VSS 1.16274f
C15 A VSS 0.42529f
C16 VDD VSS 6.00341f
C17 a_469_n286# VSS 0.01616f
C18 a_323_n286# VSS 0.44193f
.ends
