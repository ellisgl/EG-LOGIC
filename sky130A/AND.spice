* NGSPICE file created from AND.ext - technology: sky130A

.subckt AND A B Y VDD VSS
X0 Y a_242_n201# VSS VSS sky130_fd_pr__nfet_01v8 ad=0.3185 pd=2.28 as=0.3185 ps=2.28 w=0.65 l=0.15
X1 a_242_n201# B VDD VDD sky130_fd_pr__pfet_01v8 ad=0.285 pd=2.57 as=0.14 ps=1.28 w=1 l=0.15
X2 Y a_242_n201# VDD VDD sky130_fd_pr__pfet_01v8 ad=0.49 pd=2.98 as=0.49 ps=2.98 w=1 l=0.15
X3 a_329_n201# A a_242_n201# VSS sky130_fd_pr__nfet_01v8 ad=0.091 pd=0.93 as=0.18525 ps=1.87 w=0.65 l=0.15
X4 VDD A a_242_n201# VDD sky130_fd_pr__pfet_01v8 ad=0.14 pd=1.28 as=0.285 ps=2.57 w=1 l=0.15
X5 VSS B a_329_n201# VSS sky130_fd_pr__nfet_01v8 ad=0.18525 pd=1.87 as=0.091 ps=0.93 w=0.65 l=0.15
C0 a_242_n201# a_329_n201# 0.00891f
C1 a_242_n201# VDD 0.46374f
C2 a_242_n201# A 0.04393f
C3 a_242_n201# B 0.05604f
C4 a_242_n201# Y 0.05622f
C5 a_329_n201# VDD 0
C6 VDD A 0.38371f
C7 VDD B 0.07775f
C8 VDD Y 0.26158f
C9 A B 0.08477f
C10 A Y 0
C11 B Y 0
C12 Y VSS 0.4237f
C13 B VSS 0.81961f
C14 A VSS 0.40204f
C15 VDD VSS 3.0499f
C16 a_329_n201# VSS 0.01072f
C17 a_242_n201# VSS 0.26506f
.ends
