* AND reference (gf180mcuD)
.subckt AND A B Y VDD VSS
X1 x A VDD VDD pfet_03v3 w=2u l=0.28u
X2 VDD B x VDD pfet_03v3 w=2u l=0.28u
X3 x A n0_1 VSS nfet_03v3 w=1u l=0.28u
X4 n0_1 B VSS VSS nfet_03v3 w=1u l=0.28u
X5 VDD x Y VDD pfet_03v3 w=2u l=0.28u
X6 VSS x Y VSS nfet_03v3 w=1u l=0.28u
.ends
