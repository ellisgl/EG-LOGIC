* NGSPICE file created from OR.ext - technology: sky130A

.subckt OR A B Y VDD VSS
X0 Y a_407_n201# VDD VDD sky130_fd_pr__pfet_01v8 ad=0.49 pd=2.98 as=0.49 ps=2.98 w=1 l=0.15
X1 VSS A a_407_n201# VSS sky130_fd_pr__nfet_01v8 ad=0.091 pd=0.93 as=0.18525 ps=1.87 w=0.65 l=0.15
X2 a_407_n201# B VSS VSS sky130_fd_pr__nfet_01v8 ad=0.18525 pd=1.87 as=0.091 ps=0.93 w=0.65 l=0.15
X3 VDD B a_494_80# VDD sky130_fd_pr__pfet_01v8 ad=0.285 pd=2.57 as=0.14 ps=1.28 w=1 l=0.15
X4 Y a_407_n201# VSS VSS sky130_fd_pr__nfet_01v8 ad=0.3185 pd=2.28 as=0.3185 ps=2.28 w=0.65 l=0.15
X5 a_494_80# A a_407_n201# VDD sky130_fd_pr__pfet_01v8 ad=0.14 pd=1.28 as=0.285 ps=2.57 w=1 l=0.15
C0 a_407_n201# a_494_80# 0.01259f
C1 a_407_n201# VDD 0.29532f
C2 a_407_n201# A 0.04371f
C3 a_407_n201# B 0.05381f
C4 a_407_n201# Y 0.05582f
C5 a_494_80# VDD 0.01661f
C6 VDD A 0.39741f
C7 VDD B 0.07601f
C8 VDD Y 0.29718f
C9 A B 0.08856f
C10 A Y 0
C11 B Y 0
C12 Y VSS 0.48496f
C13 B VSS 0.93218f
C14 A VSS 0.48762f
C15 VDD VSS 3.44497f
C16 a_494_80# VSS 0
C17 a_407_n201# VSS 0.38357f
.ends
