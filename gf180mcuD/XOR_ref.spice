* XOR reference (gf180mcuD)
.subckt XOR A B Y VDD VSS
X1 c A p0_1 VDD pfet_03v3 w=2u l=0.28u
X2 p0_1 B VDD VDD pfet_03v3 w=2u l=0.28u
X3 c A VSS VSS nfet_03v3 w=1u l=0.28u
X4 VSS B c VSS nfet_03v3 w=1u l=0.28u
X5 p1 A VDD VDD pfet_03v3 w=2u l=0.28u
X6 VDD B p1 VDD pfet_03v3 w=2u l=0.28u
X7 p1 c Y VDD pfet_03v3 w=2u l=0.28u
X8 Y A n1_1 VSS nfet_03v3 w=1u l=0.28u
X9 n1_1 B VSS VSS nfet_03v3 w=1u l=0.28u
X10 VSS c Y VSS nfet_03v3 w=1u l=0.28u
.ends
