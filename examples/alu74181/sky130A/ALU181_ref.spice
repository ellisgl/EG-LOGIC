* ALU181 reference (sky130A)
* AND reference (sky130A)
.subckt AND A B Y VDD VSS
X1 x A VDD VDD sky130_fd_pr__pfet_01v8 w=1 l=0.15
X2 VDD B x VDD sky130_fd_pr__pfet_01v8 w=1 l=0.15
X3 x A n0_1 VSS sky130_fd_pr__nfet_01v8 w=0.65 l=0.15
X4 n0_1 B VSS VSS sky130_fd_pr__nfet_01v8 w=0.65 l=0.15
X5 VDD x Y VDD sky130_fd_pr__pfet_01v8 w=1 l=0.15
X6 VSS x Y VSS sky130_fd_pr__nfet_01v8 w=0.65 l=0.15
.ends

* NAND reference (sky130A)
.subckt NAND A B Y VDD VSS
X1 Y A VDD VDD sky130_fd_pr__pfet_01v8 w=1 l=0.15
X2 VDD B Y VDD sky130_fd_pr__pfet_01v8 w=1 l=0.15
X3 Y A n0_1 VSS sky130_fd_pr__nfet_01v8 w=0.65 l=0.15
X4 n0_1 B VSS VSS sky130_fd_pr__nfet_01v8 w=0.65 l=0.15
.ends

* NOR reference (sky130A)
.subckt NOR A B Y VDD VSS
X1 Y A p0_1 VDD sky130_fd_pr__pfet_01v8 w=1 l=0.15
X2 p0_1 B VDD VDD sky130_fd_pr__pfet_01v8 w=1 l=0.15
X3 Y A VSS VSS sky130_fd_pr__nfet_01v8 w=0.65 l=0.15
X4 VSS B Y VSS sky130_fd_pr__nfet_01v8 w=0.65 l=0.15
.ends

* NOT reference (sky130A)
.subckt NOT A Y VDD VSS
X1 VDD A Y VDD sky130_fd_pr__pfet_01v8 w=1 l=0.15
X2 VSS A Y VSS sky130_fd_pr__nfet_01v8 w=0.65 l=0.15
.ends

* OR reference (sky130A)
.subckt OR A B Y VDD VSS
X1 x A p0_1 VDD sky130_fd_pr__pfet_01v8 w=1 l=0.15
X2 p0_1 B VDD VDD sky130_fd_pr__pfet_01v8 w=1 l=0.15
X3 x A VSS VSS sky130_fd_pr__nfet_01v8 w=0.65 l=0.15
X4 VSS B x VSS sky130_fd_pr__nfet_01v8 w=0.65 l=0.15
X5 VDD x Y VDD sky130_fd_pr__pfet_01v8 w=1 l=0.15
X6 VSS x Y VSS sky130_fd_pr__nfet_01v8 w=0.65 l=0.15
.ends

* XOR reference (sky130A)
.subckt XOR A B Y VDD VSS
X1 c A p0_1 VDD sky130_fd_pr__pfet_01v8 w=1 l=0.15
X2 p0_1 B VDD VDD sky130_fd_pr__pfet_01v8 w=1 l=0.15
X3 c A VSS VSS sky130_fd_pr__nfet_01v8 w=0.65 l=0.15
X4 VSS B c VSS sky130_fd_pr__nfet_01v8 w=0.65 l=0.15
X5 p1 A VDD VDD sky130_fd_pr__pfet_01v8 w=1 l=0.15
X6 VDD B p1 VDD sky130_fd_pr__pfet_01v8 w=1 l=0.15
X7 p1 c Y VDD sky130_fd_pr__pfet_01v8 w=1 l=0.15
X8 Y A n1_1 VSS sky130_fd_pr__nfet_01v8 w=0.65 l=0.15
X9 n1_1 B VSS VSS sky130_fd_pr__nfet_01v8 w=0.65 l=0.15
X10 VSS c Y VSS sky130_fd_pr__nfet_01v8 w=0.65 l=0.15
.ends

.subckt ALU181 A0 A1 A2 A3 B0 B1 B2 B3 S0 S1 S2 S3 M Cn F0 F1 F2 F3 AEQB P_N G_N Cn4 VDD VSS
XNOT_ncn Cn c0 VDD VSS NOT
XNOT_nb0 B0 nB0 VDD VSS NOT
XNAND_a1_0 B0 S0 a1_0 VDD VSS NAND
XNAND_a2_0 nB0 S1 a2_0 VDD VSS NAND
XNAND_u0 a1_0 a2_0 u0 VDD VSS NAND
XOR_p0 A0 u0 p0 VDD VSS OR
XNAND_a3_0 nB0 S2 a3_0 VDD VSS NAND
XNAND_a4_0 B0 S3 a4_0 VDD VSS NAND
XNAND_v0 a3_0 a4_0 v0 VDD VSS NAND
XAND_g0 A0 v0 g0 VDD VSS AND
XXOR_h0 p0 g0 h0 VDD VSS XOR
XOR_k0 M c0 k0 VDD VSS OR
XXOR_f0 h0 k0 F0 VDD VSS XOR
XAND_pc0 p0 c0 pc0 VDD VSS AND
XOR_cy0 g0 pc0 c1 VDD VSS OR
XNOT_nb1 B1 nB1 VDD VSS NOT
XNAND_a1_1 B1 S0 a1_1 VDD VSS NAND
XNAND_a2_1 nB1 S1 a2_1 VDD VSS NAND
XNAND_u1 a1_1 a2_1 u1 VDD VSS NAND
XOR_p1 A1 u1 p1 VDD VSS OR
XNAND_a3_1 nB1 S2 a3_1 VDD VSS NAND
XNAND_a4_1 B1 S3 a4_1 VDD VSS NAND
XNAND_v1 a3_1 a4_1 v1 VDD VSS NAND
XAND_g1 A1 v1 g1 VDD VSS AND
XXOR_h1 p1 g1 h1 VDD VSS XOR
XOR_k1 M c1 k1 VDD VSS OR
XXOR_f1 h1 k1 F1 VDD VSS XOR
XAND_pc1 p1 c1 pc1 VDD VSS AND
XOR_cy1 g1 pc1 c2 VDD VSS OR
XNOT_nb2 B2 nB2 VDD VSS NOT
XNAND_a1_2 B2 S0 a1_2 VDD VSS NAND
XNAND_a2_2 nB2 S1 a2_2 VDD VSS NAND
XNAND_u2 a1_2 a2_2 u2 VDD VSS NAND
XOR_p2 A2 u2 p2 VDD VSS OR
XNAND_a3_2 nB2 S2 a3_2 VDD VSS NAND
XNAND_a4_2 B2 S3 a4_2 VDD VSS NAND
XNAND_v2 a3_2 a4_2 v2 VDD VSS NAND
XAND_g2 A2 v2 g2 VDD VSS AND
XXOR_h2 p2 g2 h2 VDD VSS XOR
XOR_k2 M c2 k2 VDD VSS OR
XXOR_f2 h2 k2 F2 VDD VSS XOR
XAND_pc2 p2 c2 pc2 VDD VSS AND
XOR_cy2 g2 pc2 c3 VDD VSS OR
XNOT_nb3 B3 nB3 VDD VSS NOT
XNAND_a1_3 B3 S0 a1_3 VDD VSS NAND
XNAND_a2_3 nB3 S1 a2_3 VDD VSS NAND
XNAND_u3 a1_3 a2_3 u3 VDD VSS NAND
XOR_p3 A3 u3 p3 VDD VSS OR
XNAND_a3_3 nB3 S2 a3_3 VDD VSS NAND
XNAND_a4_3 B3 S3 a4_3 VDD VSS NAND
XNAND_v3 a3_3 a4_3 v3 VDD VSS NAND
XAND_g3 A3 v3 g3 VDD VSS AND
XXOR_h3 p3 g3 h3 VDD VSS XOR
XOR_k3 M c3 k3 VDD VSS OR
XXOR_f3 h3 k3 F3 VDD VSS XOR
XAND_pc3 p3 c3 pc3 VDD VSS AND
XOR_cy3 g3 pc3 c4 VDD VSS OR
XNOT_ncout c4 Cn4 VDD VSS NOT
XAND_pp01 p0 p1 pp01 VDD VSS AND
XAND_pp23 p2 p3 pp23 VDD VSS AND
XNAND_pg pp01 pp23 P_N VDD VSS NAND
XAND_q1 p1 g0 q1 VDD VSS AND
XOR_gr1 g1 q1 gr1 VDD VSS OR
XAND_q2 p2 gr1 q2 VDD VSS AND
XOR_gr2 g2 q2 gr2 VDD VSS OR
XAND_q3 p3 gr2 q3 VDD VSS AND
XNOR_gg g3 q3 G_N VDD VSS NOR
XAND_e01 F0 F1 e01 VDD VSS AND
XAND_e23 F2 F3 e23 VDD VSS AND
XAND_eq e01 e23 AEQB VDD VSS AND
.ends
