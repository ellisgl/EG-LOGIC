* ADD4 exhaustive test (gf180mcuD)
.include /home/ellis/pdk/gf180mcuD/libs.tech/ngspice/design.ngspice
.lib /home/ellis/pdk/gf180mcuD/libs.tech/ngspice/sm141064.ngspice typical

* NGSPICE file created from ADD4.ext - technology: gf180mcuD

.subckt AND A B Y VDD VSS a_323_n286# a_469_n286#
M0 VDD A a_323_n286# VDD pfet_03v3 ad=0.53p pd=2.53u as=0.9p ps=4.9u w=2u l=0.28u
M1 a_469_n286# A a_323_n286# VSS nfet_03v3 ad=0.265p pd=1.53u as=0.45p ps=2.9u w=1u l=0.28u
M2 Y a_323_n286# VSS VSS nfet_03v3 ad=0.625p pd=3.25u as=0.625p ps=3.25u w=1u l=0.28u
M3 VSS B a_469_n286# VSS nfet_03v3 ad=0.45p pd=2.9u as=0.265p ps=1.53u w=1u l=0.28u
M4 Y a_323_n286# VDD VDD pfet_03v3 ad=1.25p pd=5.25u as=1.25p ps=5.25u w=2u l=0.28u
M5 a_323_n286# B VDD VDD pfet_03v3 ad=0.9p pd=4.9u as=0.53p ps=2.53u w=2u l=0.28u
C0 a_323_n286# a_469_n286# 0.01435f
C1 a_323_n286# VDD 1.15177f
C2 a_323_n286# A 0.06277f
C3 a_323_n286# B 0.07031f
C4 a_323_n286# Y 0.12848f
C5 a_469_n286# VDD 0.00121f
C6 a_469_n286# Y 0
C7 VDD A 0.58621f
C8 VDD B 0.12259f
C9 VDD Y 0.55505f
C10 A B 0.05053f
C11 A Y 0
C12 B Y 0
C13 Y VSS 0.64505f
C14 B VSS 1.16274f
C15 A VSS 0.42529f
C16 VDD VSS 6.00341f
C17 a_469_n286# VSS 0.01616f
C18 a_323_n286# VSS 0.44193f
.ends

.subckt XOR A B Y VDD VSS a_1155_195# a_1609_n395# m1_n57_n1110# m2_n57_n1110# a_1009_n395#
+ a_1463_195#
M0 Y a_1009_n395# a_1463_195# VDD pfet_03v3 ad=1.25p pd=5.25u as=0.705p ps=2.705u w=2u l=0.28u
M1 a_1463_195# B VDD VDD pfet_03v3 ad=0.705p pd=2.705u as=0.53p ps=2.53u w=2u l=0.28u
M2 VDD A a_1463_195# VDD pfet_03v3 ad=0.53p pd=2.53u as=0.9p ps=4.9u w=2u l=0.28u
M3 a_1009_n395# B VSS VSS nfet_03v3 ad=0.45p pd=2.9u as=0.265p ps=1.53u w=1u l=0.28u
M4 a_1609_n395# A Y VSS nfet_03v3 ad=0.265p pd=1.53u as=0.45p ps=2.9u w=1u l=0.28u
M5 VDD B a_1155_195# VDD pfet_03v3 ad=0.9p pd=4.9u as=0.53p ps=2.53u w=2u l=0.28u
M6 VSS B a_1609_n395# VSS nfet_03v3 ad=0.3525p pd=1.705u as=0.265p ps=1.53u w=1u l=0.28u
M7 a_1155_195# A a_1009_n395# VDD pfet_03v3 ad=0.53p pd=2.53u as=0.9p ps=4.9u w=2u l=0.28u
M8 VSS A a_1009_n395# VSS nfet_03v3 ad=0.265p pd=1.53u as=0.45p ps=2.9u w=1u l=0.28u
M9 Y a_1009_n395# VSS VSS nfet_03v3 ad=0.625p pd=3.25u as=0.3525p ps=1.705u w=1u l=0.28u
C0 a_1009_n395# a_1155_195# 0.02315f
C1 a_1009_n395# a_1463_195# 0.49044f
C2 a_1009_n395# m1_n57_n1110# 0.01171f
C3 a_1009_n395# m2_n57_n1110# 0.00242f
C4 a_1009_n395# VDD 0.63712f
C5 a_1009_n395# A 0.09858f
C6 a_1009_n395# B 0.12558f
C7 a_1009_n395# Y 0.97225f
C8 a_1155_195# a_1463_195# 0
C9 a_1155_195# VDD 0.03214f
C10 a_1463_195# m2_n57_n1110# 0
C11 a_1463_195# VDD 0.83682f
C12 a_1463_195# A 0.04667f
C13 a_1463_195# B 0.04491f
C14 a_1463_195# Y 0.14545f
C15 a_1609_n395# VDD 0
C16 a_1609_n395# Y 0.01483f
C17 m1_n57_n1110# m2_n57_n1110# 0.55172f
C18 m1_n57_n1110# VDD 0.14282f
C19 m1_n57_n1110# A 0.07093f
C20 m1_n57_n1110# B 0.06992f
C21 m2_n57_n1110# VDD 0.13215f
C22 m2_n57_n1110# A 0.01915f
C23 m2_n57_n1110# B 0.01901f
C24 m2_n57_n1110# Y 0
C25 VDD A 1.14567f
C26 VDD B 0.31693f
C27 VDD Y 0.57323f
C28 A B 0.19007f
C29 A Y 0.03021f
C30 B Y 0.03299f
C31 Y VSS 1.00565f
C32 B VSS 2.34945f
C33 A VSS 1.14285f
C34 VDD VSS 8.40014f
C35 m2_n57_n1110# VSS 0.80082f
C36 m1_n57_n1110# VSS 1.26958f
C37 a_1609_n395# VSS 0.01427f
C38 a_1463_195# VSS 0.00312f
C39 a_1155_195# VSS 0.0013f
C40 a_1009_n395# VSS 0.69678f
.ends

.subckt OR A B Y VDD VSS a_651_86# a_505_n286#
M0 VDD B a_651_86# VDD pfet_03v3 ad=0.9p pd=4.9u as=0.53p ps=2.53u w=2u l=0.28u
M1 VSS A a_505_n286# VSS nfet_03v3 ad=0.265p pd=1.53u as=0.45p ps=2.9u w=1u l=0.28u
M2 a_651_86# A a_505_n286# VDD pfet_03v3 ad=0.53p pd=2.53u as=0.9p ps=4.9u w=2u l=0.28u
M3 a_505_n286# B VSS VSS nfet_03v3 ad=0.45p pd=2.9u as=0.265p ps=1.53u w=1u l=0.28u
M4 Y a_505_n286# VSS VSS nfet_03v3 ad=0.625p pd=3.25u as=0.625p ps=3.25u w=1u l=0.28u
M5 Y a_505_n286# VDD VDD pfet_03v3 ad=1.25p pd=5.25u as=1.25p ps=5.25u w=2u l=0.28u
C0 a_505_n286# a_651_86# 0.02609f
C1 a_505_n286# VDD 0.60195f
C2 a_505_n286# A 0.06265f
C3 a_505_n286# B 0.06594f
C4 a_505_n286# Y 0.12779f
C5 a_651_86# VDD 0.03536f
C6 a_651_86# Y 0
C7 VDD A 0.59831f
C8 VDD B 0.11999f
C9 VDD Y 0.63118f
C10 A B 0.05231f
C11 A Y 0
C12 B Y 0
C13 Y VSS 0.74439f
C14 B VSS 1.30453f
C15 A VSS 0.5295f
C16 VDD VSS 6.17565f
C17 a_651_86# VSS 0.00201f
C18 a_505_n286# VSS 0.79095f
.ends

.subckt ADD4 A0 A1 A2 A3 B0 B1 B2 B3 Cin S0 S1 S2 S3 Cout VDD VSS
XAND_3_3 XOR_3_2/A OR_2_4/Y OR_3_4/B VDD VSS AND_3_3/a_323_n286# AND_3_3/a_469_n286#
+ AND
XXOR_2_0 A2 B2 XOR_2_2/A VDD VSS XOR_2_0/a_1155_195# XOR_2_0/a_1609_n395# XOR_2_0/m1_n57_n1110#
+ XOR_2_0/m2_n57_n1110# XOR_2_0/a_1009_n395# XOR_2_0/a_1463_195# XOR
XAND_1_1 A1 B1 OR_1_4/A VDD VSS AND_1_1/a_323_n286# AND_1_1/a_469_n286# AND
XXOR_2_2 XOR_2_2/A OR_1_4/Y S2 VDD VSS XOR_2_2/a_1155_195# XOR_2_2/a_1609_n395# XOR_2_2/m1_n57_n1110#
+ XOR_2_2/m2_n57_n1110# XOR_2_2/a_1009_n395# XOR_2_2/a_1463_195# XOR
XAND_1_3 XOR_1_2/A OR_0_4/Y OR_1_4/B VDD VSS AND_1_3/a_323_n286# AND_1_3/a_469_n286#
+ AND
XXOR_0_0 A0 B0 XOR_0_2/A VDD VSS XOR_0_0/a_1155_195# XOR_0_0/a_1609_n395# XOR_0_0/m1_n57_n1110#
+ XOR_0_0/m2_n57_n1110# XOR_0_0/a_1009_n395# XOR_0_0/a_1463_195# XOR
XXOR_0_2 XOR_0_2/A Cin S0 VDD VSS XOR_0_2/a_1155_195# XOR_0_2/a_1609_n395# XOR_0_2/m1_n57_n1110#
+ XOR_0_2/m2_n57_n1110# XOR_0_2/a_1009_n395# XOR_0_2/a_1463_195# XOR
XOR_2_4 OR_2_4/A OR_2_4/B OR_2_4/Y VDD VSS OR_2_4/a_651_86# OR_2_4/a_505_n286# OR
XOR_0_4 OR_0_4/A OR_0_4/B OR_0_4/Y VDD VSS OR_0_4/a_651_86# OR_0_4/a_505_n286# OR
XAND_2_1 A2 B2 OR_2_4/A VDD VSS AND_2_1/a_323_n286# AND_2_1/a_469_n286# AND
XXOR_3_0 A3 B3 XOR_3_2/A VDD VSS XOR_3_0/a_1155_195# XOR_3_0/a_1609_n395# XOR_3_0/m1_n57_n1110#
+ XOR_3_0/m2_n57_n1110# XOR_3_0/a_1009_n395# XOR_3_0/a_1463_195# XOR
XXOR_3_2 XOR_3_2/A OR_2_4/Y S3 VDD VSS XOR_3_2/a_1155_195# XOR_3_2/a_1609_n395# XOR_3_2/m1_n57_n1110#
+ XOR_3_2/m2_n57_n1110# XOR_3_2/a_1009_n395# XOR_3_2/a_1463_195# XOR
XAND_2_3 XOR_2_2/A OR_1_4/Y OR_2_4/B VDD VSS AND_2_3/a_323_n286# AND_2_3/a_469_n286#
+ AND
XXOR_1_0 A1 B1 XOR_1_2/A VDD VSS XOR_1_0/a_1155_195# XOR_1_0/a_1609_n395# XOR_1_0/m1_n57_n1110#
+ XOR_1_0/m2_n57_n1110# XOR_1_0/a_1009_n395# XOR_1_0/a_1463_195# XOR
XAND_0_1 A0 B0 OR_0_4/A VDD VSS AND_0_1/a_323_n286# AND_0_1/a_469_n286# AND
XXOR_1_2 XOR_1_2/A OR_0_4/Y S1 VDD VSS XOR_1_2/a_1155_195# XOR_1_2/a_1609_n395# XOR_1_2/m1_n57_n1110#
+ XOR_1_2/m2_n57_n1110# XOR_1_2/a_1009_n395# XOR_1_2/a_1463_195# XOR
XAND_0_3 XOR_0_2/A Cin OR_0_4/B VDD VSS AND_0_3/a_323_n286# AND_0_3/a_469_n286# AND
XOR_3_4 OR_3_4/A OR_3_4/B Cout VDD VSS OR_3_4/a_651_86# OR_3_4/a_505_n286# OR
XOR_1_4 OR_1_4/A OR_1_4/B OR_1_4/Y VDD VSS OR_1_4/a_651_86# OR_1_4/a_505_n286# OR
XAND_3_1 A3 B3 OR_3_4/A VDD VSS AND_3_1/a_323_n286# AND_3_1/a_469_n286# AND
C0 AND_3_3/a_323_n286# OR_3_4/B 0
C1 AND_3_3/a_323_n286# VDD 0
C2 AND_3_3/a_323_n286# OR_2_4/Y 0.00607f
C3 AND_3_3/a_323_n286# S3 0.05109f
C4 AND_3_3/a_323_n286# OR_3_4/A 0.02161f
C5 AND_3_3/a_469_n286# OR_2_4/Y 0.00192f
C6 AND_3_3/a_469_n286# S3 0.0025f
C7 OR_3_4/B VDD 0.01055f
C8 OR_3_4/B OR_2_4/Y 0.07311f
C9 OR_3_4/B S3 0.38485f
C10 OR_3_4/B OR_3_4/a_505_n286# 0.00512f
C11 OR_3_4/B Cout 0
C12 OR_3_4/B OR_3_4/A 0.07914f
C13 XOR_2_0/a_1009_n395# A2 0.02464f
C14 XOR_2_0/a_1009_n395# B2 0.02203f
C15 XOR_2_0/a_1009_n395# XOR_2_2/A 0
C16 XOR_2_0/a_1009_n395# VDD 0
C17 XOR_2_0/a_1155_195# A2 0.00439f
C18 XOR_2_0/a_1155_195# B2 0.00211f
C19 XOR_2_0/a_1463_195# A2 0.01994f
C20 XOR_2_0/a_1463_195# B2 0.00694f
C21 XOR_2_0/a_1609_n395# A2 0.00117f
C22 XOR_2_0/a_1609_n395# B2 0.00209f
C23 XOR_2_0/m1_n57_n1110# A2 0.00831f
C24 XOR_2_0/m1_n57_n1110# B2 0.00831f
C25 XOR_2_0/m1_n57_n1110# VDD 0.01133f
C26 XOR_2_0/m1_n57_n1110# XOR_3_0/m1_n57_n1110# 0.01158f
C27 XOR_2_0/m1_n57_n1110# B3 0
C28 XOR_2_0/m1_n57_n1110# XOR_1_0/m1_n57_n1110# 0.01158f
C29 XOR_2_0/m1_n57_n1110# A1 0
C30 XOR_2_0/m2_n57_n1110# A2 0.1122f
C31 XOR_2_0/m2_n57_n1110# B2 0.1122f
C32 XOR_2_0/m2_n57_n1110# VDD 0.05165f
C33 XOR_2_0/m2_n57_n1110# XOR_3_0/m2_n57_n1110# 0.01255f
C34 XOR_2_0/m2_n57_n1110# XOR_1_0/m2_n57_n1110# 0.01255f
C35 A2 B2 0.28851f
C36 A2 XOR_2_2/A 0.17757f
C37 A2 VDD 1.16369f
C38 A2 XOR_3_0/m1_n57_n1110# 0
C39 B2 XOR_2_2/A 0.09928f
C40 B2 VDD 0.06752f
C41 B2 OR_2_4/A 0
C42 B2 XOR_1_0/m1_n57_n1110# 0
C43 XOR_2_2/A XOR_2_2/a_1009_n395# 0.0115f
C44 XOR_2_2/A XOR_2_2/a_1155_195# 0.00439f
C45 XOR_2_2/A XOR_2_2/a_1463_195# 0.01596f
C46 XOR_2_2/A XOR_2_2/m1_n57_n1110# 0.00842f
C47 XOR_2_2/A XOR_2_2/m2_n57_n1110# 0.10596f
C48 XOR_2_2/A S2 0.02094f
C49 XOR_2_2/A VDD 1.96352f
C50 XOR_2_2/A AND_2_1/a_323_n286# 0.03607f
C51 XOR_2_2/A AND_2_1/a_469_n286# 0.00132f
C52 XOR_2_2/A OR_2_4/A 0.82843f
C53 XOR_2_2/A XOR_3_2/m1_n57_n1110# 0
C54 XOR_2_2/A OR_1_4/Y 0.02835f
C55 AND_1_1/a_323_n286# OR_1_4/A 0.00117f
C56 AND_1_1/a_323_n286# VDD 0
C57 AND_1_1/a_323_n286# XOR_1_2/A 0.03607f
C58 AND_1_1/a_469_n286# XOR_1_2/A 0.00132f
C59 OR_1_4/A AND_1_3/a_323_n286# 0.02161f
C60 OR_1_4/A VDD 1.21215f
C61 OR_1_4/A OR_0_4/Y 0.36884f
C62 OR_1_4/A B1 0
C63 OR_1_4/A XOR_1_2/A 0.82843f
C64 OR_1_4/A XOR_1_2/a_1009_n395# 0.04696f
C65 OR_1_4/A XOR_1_2/a_1155_195# 0.00441f
C66 OR_1_4/A XOR_1_2/a_1463_195# 0.03298f
C67 OR_1_4/A XOR_1_2/a_1609_n395# 0.00192f
C68 OR_1_4/A XOR_1_2/m1_n57_n1110# 0.01038f
C69 OR_1_4/A XOR_1_2/m2_n57_n1110# 0.10195f
C70 OR_1_4/A S1 0.61797f
C71 OR_1_4/A OR_1_4/B 0.02713f
C72 OR_1_4/A OR_1_4/Y 0.09032f
C73 XOR_2_2/a_1009_n395# S2 0
C74 XOR_2_2/a_1009_n395# VDD 0
C75 XOR_2_2/a_1009_n395# OR_2_4/A 0.04696f
C76 XOR_2_2/a_1009_n395# OR_1_4/Y 0.0186f
C77 XOR_2_2/a_1155_195# OR_2_4/A 0.00441f
C78 XOR_2_2/a_1463_195# OR_2_4/A 0.03298f
C79 XOR_2_2/a_1463_195# OR_1_4/Y 0.00147f
C80 XOR_2_2/a_1609_n395# OR_2_4/A 0.00192f
C81 XOR_2_2/a_1609_n395# OR_1_4/Y 0.00209f
C82 XOR_2_2/m1_n57_n1110# VDD 0.01104f
C83 XOR_2_2/m1_n57_n1110# OR_2_4/Y 0
C84 XOR_2_2/m1_n57_n1110# OR_2_4/A 0.01038f
C85 XOR_2_2/m1_n57_n1110# XOR_3_2/m1_n57_n1110# 0.01158f
C86 XOR_2_2/m1_n57_n1110# XOR_1_2/A 0
C87 XOR_2_2/m1_n57_n1110# XOR_1_2/m1_n57_n1110# 0.01158f
C88 XOR_2_2/m1_n57_n1110# OR_1_4/Y 0.00754f
C89 XOR_2_2/m2_n57_n1110# VDD 0.05074f
C90 XOR_2_2/m2_n57_n1110# OR_2_4/A 0.10195f
C91 XOR_2_2/m2_n57_n1110# XOR_3_2/m2_n57_n1110# 0.01255f
C92 XOR_2_2/m2_n57_n1110# XOR_1_2/m2_n57_n1110# 0.01255f
C93 XOR_2_2/m2_n57_n1110# OR_1_4/Y 0.10992f
C94 S2 VDD 0.19184f
C95 S2 OR_2_4/a_505_n286# 0.01942f
C96 S2 OR_2_4/B 0.31946f
C97 S2 OR_2_4/Y 1.21468f
C98 S2 OR_2_4/A 0.61797f
C99 S2 AND_2_3/a_323_n286# 0.05109f
C100 S2 AND_2_3/a_469_n286# 0.0025f
C101 S2 OR_1_4/Y 0.38995f
C102 AND_1_3/a_323_n286# VDD 0
C103 AND_1_3/a_323_n286# OR_0_4/Y 0.00607f
C104 AND_1_3/a_323_n286# S1 0.05109f
C105 AND_1_3/a_323_n286# OR_1_4/B 0
C106 AND_1_3/a_469_n286# OR_0_4/Y 0.00192f
C107 AND_1_3/a_469_n286# S1 0.0025f
C108 XOR_0_0/a_1009_n395# VDD 0
C109 XOR_0_0/a_1009_n395# A0 0.02113f
C110 XOR_0_0/a_1009_n395# B0 0.00838f
C111 XOR_0_0/a_1009_n395# XOR_0_2/A 0
C112 XOR_0_0/a_1009_n395# Cin 0.04826f
C113 XOR_0_0/a_1155_195# A0 0.00439f
C114 XOR_0_0/a_1155_195# Cin 0.00351f
C115 XOR_0_0/a_1463_195# A0 0.01994f
C116 XOR_0_0/a_1463_195# Cin 0.01562f
C117 XOR_0_0/a_1609_n395# B0 0.00209f
C118 XOR_0_0/a_1609_n395# Cin 0.00231f
C119 XOR_0_0/m1_n57_n1110# VDD 0.00873f
C120 XOR_0_0/m1_n57_n1110# A0 0.00831f
C121 XOR_0_0/m1_n57_n1110# B0 0.00831f
C122 XOR_0_0/m1_n57_n1110# Cin 0.00829f
C123 XOR_0_0/m1_n57_n1110# XOR_1_0/m1_n57_n1110# 0.01158f
C124 XOR_0_0/m1_n57_n1110# B1 0
C125 XOR_0_0/m2_n57_n1110# VDD 0.04937f
C126 XOR_0_0/m2_n57_n1110# A0 0.10999f
C127 XOR_0_0/m2_n57_n1110# B0 0.10603f
C128 XOR_0_0/m2_n57_n1110# Cin 0.09925f
C129 XOR_0_0/m2_n57_n1110# XOR_1_0/m2_n57_n1110# 0.01255f
C130 VDD A0 1.16378f
C131 VDD B0 0.01213f
C132 VDD XOR_0_2/A 1.96361f
C133 VDD XOR_0_2/a_1009_n395# 0
C134 VDD XOR_0_2/m1_n57_n1110# 0.00844f
C135 VDD XOR_0_2/m2_n57_n1110# 0.04846f
C136 VDD Cin 0.15618f
C137 VDD S0 0.19185f
C138 VDD OR_2_4/a_505_n286# 0.00421f
C139 VDD OR_2_4/a_651_86# 0.00244f
C140 VDD OR_2_4/B 0.00895f
C141 VDD OR_2_4/Y 0.58601f
C142 VDD OR_0_4/a_505_n286# 0.00418f
C143 VDD OR_0_4/a_651_86# 0.00244f
C144 VDD OR_0_4/Y 0.58602f
C145 VDD AND_2_1/a_323_n286# 0
C146 VDD OR_2_4/A 1.21214f
C147 VDD XOR_3_0/a_1009_n395# 0
C148 VDD XOR_3_0/m1_n57_n1110# 0.01134f
C149 VDD XOR_3_0/m2_n57_n1110# 0.05165f
C150 VDD A3 1.16377f
C151 VDD B3 0.06752f
C152 VDD XOR_3_2/A 1.9636f
C153 VDD XOR_3_2/a_1009_n395# 0
C154 VDD XOR_3_2/m1_n57_n1110# 0.01105f
C155 VDD XOR_3_2/m2_n57_n1110# 0.05074f
C156 VDD S3 0.40392f
C157 VDD AND_2_3/a_323_n286# 0
C158 VDD XOR_1_0/a_1009_n395# 0
C159 VDD XOR_1_0/m1_n57_n1110# 0.01133f
C160 VDD XOR_1_0/m2_n57_n1110# 0.05165f
C161 VDD A1 1.16377f
C162 VDD B1 0.06752f
C163 VDD XOR_1_2/A 1.9636f
C164 VDD AND_0_1/a_323_n286# 0
C165 VDD OR_0_4/A 1.21216f
C166 VDD XOR_1_2/a_1009_n395# 0
C167 VDD XOR_1_2/m1_n57_n1110# 0.01105f
C168 VDD XOR_1_2/m2_n57_n1110# 0.05074f
C169 VDD S1 0.19185f
C170 VDD AND_0_3/a_323_n286# 0
C171 VDD OR_0_4/B 0.00535f
C172 VDD OR_3_4/a_505_n286# 0.00642f
C173 VDD OR_3_4/a_651_86# 0.00244f
C174 VDD Cout 0.0812f
C175 VDD OR_1_4/a_505_n286# 0.00421f
C176 VDD OR_1_4/a_651_86# 0.00244f
C177 VDD OR_1_4/B 0.00895f
C178 VDD OR_1_4/Y 0.58602f
C179 VDD AND_3_1/a_323_n286# 0
C180 VDD OR_3_4/A 1.21231f
C181 A0 B0 0.02551f
C182 A0 XOR_0_2/A 0.17385f
C183 A0 Cin 0.42303f
C184 A0 XOR_1_0/m1_n57_n1110# 0
C185 B0 XOR_0_2/A 0.02022f
C186 B0 Cin 0.83064f
C187 B0 OR_0_4/A 0
C188 XOR_0_2/A XOR_0_2/a_1009_n395# 0.0115f
C189 XOR_0_2/A XOR_0_2/a_1155_195# 0.00439f
C190 XOR_0_2/A XOR_0_2/a_1463_195# 0.01596f
C191 XOR_0_2/A XOR_0_2/m1_n57_n1110# 0.00842f
C192 XOR_0_2/A XOR_0_2/m2_n57_n1110# 0.10596f
C193 XOR_0_2/A Cin 0.52968f
C194 XOR_0_2/A S0 0.02094f
C195 XOR_0_2/A AND_0_1/a_323_n286# 0.03607f
C196 XOR_0_2/A AND_0_1/a_469_n286# 0.00132f
C197 XOR_0_2/A OR_0_4/A 0.82843f
C198 XOR_0_2/A XOR_1_2/m1_n57_n1110# 0
C199 XOR_0_2/a_1009_n395# Cin 0.0186f
C200 XOR_0_2/a_1009_n395# S0 0
C201 XOR_0_2/a_1009_n395# OR_0_4/A 0.04696f
C202 XOR_0_2/a_1155_195# OR_0_4/A 0.00441f
C203 XOR_0_2/a_1463_195# Cin 0.00147f
C204 XOR_0_2/a_1463_195# OR_0_4/A 0.03298f
C205 XOR_0_2/a_1609_n395# Cin 0.00209f
C206 XOR_0_2/a_1609_n395# OR_0_4/A 0.00192f
C207 XOR_0_2/m1_n57_n1110# Cin 0.00842f
C208 XOR_0_2/m1_n57_n1110# OR_0_4/Y 0
C209 XOR_0_2/m1_n57_n1110# OR_0_4/A 0.01038f
C210 XOR_0_2/m1_n57_n1110# XOR_1_2/m1_n57_n1110# 0.01158f
C211 XOR_0_2/m2_n57_n1110# Cin 0.10992f
C212 XOR_0_2/m2_n57_n1110# OR_0_4/A 0.10195f
C213 XOR_0_2/m2_n57_n1110# XOR_1_2/m2_n57_n1110# 0.01255f
C214 Cin S0 0.09832f
C215 Cin AND_0_1/a_323_n286# 0.01822f
C216 Cin AND_0_1/a_469_n286# 0.00322f
C217 Cin OR_0_4/A 0.42824f
C218 Cin OR_0_4/B 0
C219 S0 OR_0_4/a_505_n286# 0.01942f
C220 S0 OR_0_4/Y 1.21468f
C221 S0 OR_0_4/A 0.61797f
C222 S0 AND_0_3/a_323_n286# 0.05109f
C223 S0 AND_0_3/a_469_n286# 0.0025f
C224 S0 OR_0_4/B 0.28915f
C225 OR_2_4/a_505_n286# OR_2_4/B 0
C226 OR_2_4/a_505_n286# OR_2_4/Y 0.04124f
C227 OR_2_4/a_651_86# OR_2_4/Y 0.00574f
C228 OR_2_4/B OR_2_4/Y 0.04549f
C229 OR_2_4/B OR_2_4/A 0.02713f
C230 OR_2_4/B AND_2_3/a_323_n286# 0
C231 OR_2_4/B OR_1_4/Y 0.19354f
C232 OR_2_4/Y OR_2_4/A 0.09032f
C233 OR_2_4/Y XOR_3_2/A 0.02835f
C234 OR_2_4/Y XOR_3_2/a_1009_n395# 0.0186f
C235 OR_2_4/Y XOR_3_2/a_1463_195# 0.00147f
C236 OR_2_4/Y XOR_3_2/a_1609_n395# 0.00209f
C237 OR_2_4/Y XOR_3_2/m1_n57_n1110# 0.00754f
C238 OR_2_4/Y XOR_3_2/m2_n57_n1110# 0.10992f
C239 OR_2_4/Y S3 0.44324f
C240 OR_2_4/Y OR_1_4/Y 0.00857f
C241 OR_2_4/Y OR_3_4/A 0.36892f
C242 OR_0_4/a_505_n286# OR_0_4/Y 0.04124f
C243 OR_0_4/a_505_n286# OR_0_4/B 0
C244 OR_0_4/a_651_86# OR_0_4/Y 0.00574f
C245 OR_0_4/Y XOR_1_2/A 0.02835f
C246 OR_0_4/Y OR_0_4/A 0.09032f
C247 OR_0_4/Y XOR_1_2/a_1009_n395# 0.0186f
C248 OR_0_4/Y XOR_1_2/a_1463_195# 0.00147f
C249 OR_0_4/Y XOR_1_2/a_1609_n395# 0.00209f
C250 OR_0_4/Y XOR_1_2/m1_n57_n1110# 0.00754f
C251 OR_0_4/Y XOR_1_2/m2_n57_n1110# 0.10991f
C252 OR_0_4/Y S1 0.38995f
C253 OR_0_4/Y OR_0_4/B 0.04526f
C254 OR_0_4/Y OR_1_4/B 0.19354f
C255 OR_0_4/Y OR_1_4/Y 0.00857f
C256 AND_2_1/a_323_n286# OR_2_4/A 0.00117f
C257 OR_2_4/A AND_2_3/a_323_n286# 0.02161f
C258 OR_2_4/A OR_1_4/Y 0.36884f
C259 XOR_3_0/a_1009_n395# A3 0.02464f
C260 XOR_3_0/a_1009_n395# B3 0.02203f
C261 XOR_3_0/a_1009_n395# XOR_3_2/A 0
C262 XOR_3_0/a_1155_195# A3 0.00439f
C263 XOR_3_0/a_1155_195# B3 0.00211f
C264 XOR_3_0/a_1463_195# A3 0.01994f
C265 XOR_3_0/a_1463_195# B3 0.00694f
C266 XOR_3_0/a_1609_n395# A3 0.00117f
C267 XOR_3_0/a_1609_n395# B3 0.00209f
C268 XOR_3_0/m1_n57_n1110# A3 0.00831f
C269 XOR_3_0/m1_n57_n1110# B3 0.00831f
C270 XOR_3_0/m2_n57_n1110# A3 0.1122f
C271 XOR_3_0/m2_n57_n1110# B3 0.1122f
C272 A3 B3 0.28851f
C273 A3 XOR_3_2/A 0.17757f
C274 B3 XOR_3_2/A 0.09928f
C275 B3 OR_3_4/A 0
C276 XOR_3_2/A XOR_3_2/a_1009_n395# 0.0115f
C277 XOR_3_2/A XOR_3_2/a_1155_195# 0.00439f
C278 XOR_3_2/A XOR_3_2/a_1463_195# 0.01596f
C279 XOR_3_2/A XOR_3_2/m1_n57_n1110# 0.00842f
C280 XOR_3_2/A XOR_3_2/m2_n57_n1110# 0.10596f
C281 XOR_3_2/A S3 0.02094f
C282 XOR_3_2/A AND_3_1/a_323_n286# 0.03607f
C283 XOR_3_2/A AND_3_1/a_469_n286# 0.00132f
C284 XOR_3_2/A OR_3_4/A 0.82843f
C285 XOR_3_2/a_1009_n395# S3 0
C286 XOR_3_2/a_1009_n395# OR_3_4/A 0.04696f
C287 XOR_3_2/a_1155_195# OR_3_4/A 0.00441f
C288 XOR_3_2/a_1463_195# OR_3_4/A 0.03298f
C289 XOR_3_2/a_1609_n395# OR_3_4/A 0.00192f
C290 XOR_3_2/m1_n57_n1110# OR_3_4/A 0.01038f
C291 XOR_3_2/m2_n57_n1110# OR_3_4/A 0.10195f
C292 S3 OR_3_4/a_505_n286# 0.03662f
C293 S3 OR_3_4/a_651_86# 0.00386f
C294 S3 Cout 0.41883f
C295 S3 OR_3_4/A 0.60426f
C296 AND_2_3/a_323_n286# OR_1_4/Y 0.00607f
C297 AND_2_3/a_469_n286# OR_1_4/Y 0.00192f
C298 XOR_1_0/a_1009_n395# A1 0.02464f
C299 XOR_1_0/a_1009_n395# B1 0.02203f
C300 XOR_1_0/a_1009_n395# XOR_1_2/A 0
C301 XOR_1_0/a_1155_195# A1 0.00439f
C302 XOR_1_0/a_1155_195# B1 0.00211f
C303 XOR_1_0/a_1463_195# A1 0.01994f
C304 XOR_1_0/a_1463_195# B1 0.00694f
C305 XOR_1_0/a_1609_n395# A1 0.00117f
C306 XOR_1_0/a_1609_n395# B1 0.00209f
C307 XOR_1_0/m1_n57_n1110# A1 0.00831f
C308 XOR_1_0/m1_n57_n1110# B1 0.00831f
C309 XOR_1_0/m2_n57_n1110# A1 0.1122f
C310 XOR_1_0/m2_n57_n1110# B1 0.11218f
C311 A1 B1 0.28851f
C312 A1 XOR_1_2/A 0.17757f
C313 B1 XOR_1_2/A 0.09928f
C314 XOR_1_2/A XOR_1_2/a_1009_n395# 0.0115f
C315 XOR_1_2/A XOR_1_2/a_1155_195# 0.00439f
C316 XOR_1_2/A XOR_1_2/a_1463_195# 0.01596f
C317 XOR_1_2/A XOR_1_2/m1_n57_n1110# 0.00842f
C318 XOR_1_2/A XOR_1_2/m2_n57_n1110# 0.10596f
C319 XOR_1_2/A S1 0.02094f
C320 AND_0_1/a_323_n286# OR_0_4/A 0.00117f
C321 OR_0_4/A AND_0_3/a_323_n286# 0.02161f
C322 OR_0_4/A OR_0_4/B 0.027f
C323 XOR_1_2/a_1009_n395# S1 0
C324 XOR_1_2/m1_n57_n1110# OR_1_4/Y 0
C325 S1 OR_1_4/a_505_n286# 0.01942f
C326 S1 OR_1_4/B 0.31946f
C327 S1 OR_1_4/Y 1.21468f
C328 AND_0_3/a_323_n286# OR_0_4/B 0
C329 OR_3_4/a_505_n286# Cout 0
C330 OR_1_4/a_505_n286# OR_1_4/B 0
C331 OR_1_4/a_505_n286# OR_1_4/Y 0.04124f
C332 OR_1_4/a_651_86# OR_1_4/Y 0.00574f
C333 OR_1_4/B OR_1_4/Y 0.04549f
C334 AND_3_1/a_323_n286# OR_3_4/A 0.00117f
C335 OR_3_4/A VSS 0.61454f
C336 AND_3_1/a_469_n286# VSS 0.00109f
C337 AND_3_1/a_323_n286# VSS 0.00638f
C338 OR_1_4/Y VSS 2.90557f
C339 OR_1_4/B VSS 0.4333f
C340 OR_1_4/a_505_n286# VSS 0.0016f
C341 Cout VSS 0.4316f
C342 OR_3_4/a_505_n286# VSS 0.00152f
C343 OR_0_4/B VSS 0.51276f
C344 AND_0_3/a_469_n286# VSS 0.00109f
C345 AND_0_3/a_323_n286# VSS 0.00225f
C346 S1 VSS 0.79242f
C347 XOR_1_2/m2_n57_n1110# VSS 0.05074f
C348 XOR_1_2/m1_n57_n1110# VSS 0.01104f
C349 XOR_1_2/a_1009_n395# VSS 0
C350 OR_0_4/A VSS 0.57693f
C351 AND_0_1/a_323_n286# VSS 0
C352 XOR_1_2/A VSS 1.14264f
C353 B1 VSS 1.7364f
C354 A1 VSS 0.61487f
C355 XOR_1_0/m2_n57_n1110# VSS 0.05074f
C356 XOR_1_0/m1_n57_n1110# VSS 0.01104f
C357 XOR_1_0/a_1009_n395# VSS 0
C358 AND_2_3/a_323_n286# VSS 0
C359 S3 VSS 0.79796f
C360 XOR_3_2/m2_n57_n1110# VSS 0.04846f
C361 XOR_3_2/m1_n57_n1110# VSS 0.00844f
C362 XOR_3_2/a_1009_n395# VSS 0
C363 XOR_3_2/A VSS 1.13405f
C364 B3 VSS 1.73621f
C365 A3 VSS 0.60605f
C366 XOR_3_0/m2_n57_n1110# VSS 0.04846f
C367 XOR_3_0/m1_n57_n1110# VSS 0.00844f
C368 XOR_3_0/a_1009_n395# VSS 0
C369 OR_2_4/A VSS 0.62034f
C370 AND_2_1/a_469_n286# VSS 0.00109f
C371 AND_2_1/a_323_n286# VSS 0.00646f
C372 OR_0_4/Y VSS 2.94036f
C373 OR_0_4/a_505_n286# VSS 0.0016f
C374 OR_2_4/Y VSS 2.90561f
C375 OR_2_4/B VSS 0.4333f
C376 OR_2_4/a_505_n286# VSS 0.0016f
C377 S0 VSS 0.99794f
C378 Cin VSS 3.68562f
C379 XOR_0_2/m2_n57_n1110# VSS 0.05074f
C380 XOR_0_2/m1_n57_n1110# VSS 0.01105f
C381 XOR_0_2/a_1009_n395# VSS 0
C382 XOR_0_2/A VSS 0.92495f
C383 B0 VSS 1.59104f
C384 A0 VSS 0.51908f
C385 VDD VSS 29.71555f
C386 XOR_0_0/m2_n57_n1110# VSS 0.05074f
C387 XOR_0_0/m1_n57_n1110# VSS 0.01105f
C388 XOR_0_0/a_1009_n395# VSS 0
C389 AND_1_3/a_323_n286# VSS 0
C390 S2 VSS 0.79244f
C391 XOR_2_2/m2_n57_n1110# VSS 0.05072f
C392 XOR_2_2/m1_n57_n1110# VSS 0.01103f
C393 XOR_2_2/a_1009_n395# VSS 0
C394 OR_1_4/A VSS 0.62034f
C395 AND_1_1/a_469_n286# VSS 0.00109f
C396 AND_1_1/a_323_n286# VSS 0.00646f
C397 XOR_2_2/A VSS 1.14264f
C398 B2 VSS 1.73635f
C399 A2 VSS 0.61487f
C400 XOR_2_0/m2_n57_n1110# VSS 0.05072f
C401 XOR_2_0/m1_n57_n1110# VSS 0.01103f
C402 XOR_2_0/a_1009_n395# VSS 0
C403 OR_3_4/B VSS 0.43297f
C404 AND_3_3/a_323_n286# VSS 0
.ends

XDUT A0 A1 A2 A3 B0 B1 B2 B3 Cin S0 S1 S2 S3 Cout VDD VSS ADD4
VDD VDD 0 3.3
VSS VSS 0 0
VA0 A0 0 PWL(0 0 3e-09 0 3.05e-09 3.3 6e-09 3.3 6.05e-09 3.3 9e-09 3.3 9.05e-09 0 1.2e-08 0 1.205e-08 0 1.5e-08 0 1.505e-08 3.3 1.8e-08 3.3 1.805e-08 3.3 2.1e-08 3.3 2.105e-08 0 2.4e-08 0 2.405e-08 0 2.7e-08 0 2.705e-08 3.3 3e-08 3.3 3.005e-08 3.3 3.3e-08 3.3 3.305e-08 0 3.6e-08 0 3.605e-08 0 3.9e-08 0 3.905e-08 3.3 4.2e-08 3.3 4.205e-08 3.3 4.5e-08 3.3 4.505e-08 0 4.8e-08 0 4.805e-08 0 5.1e-08 0 5.105e-08 3.3 5.4e-08 3.3 5.405e-08 3.3 5.7e-08 3.3 5.705e-08 0 6e-08 0 6.005e-08 0 6.3e-08 0 6.305e-08 3.3 6.6e-08 3.3 6.605e-08 3.3 6.9e-08 3.3 6.905e-08 0 7.2e-08 0 7.205e-08 0 7.5e-08 0 7.505e-08 3.3 7.8e-08 3.3 7.805e-08 3.3 8.1e-08 3.3 8.105e-08 0 8.4e-08 0 8.405e-08 0 8.7e-08 0 8.705e-08 3.3 9e-08 3.3 9.005e-08 3.3 9.3e-08 3.3 9.305e-08 0 9.6e-08 0 9.605e-08 0 9.9e-08 0 9.905e-08 3.3 1.02e-07 3.3 1.021e-07 3.3 1.05e-07 3.3 1.051e-07 0 1.08e-07 0 1.081e-07 0 1.11e-07 0 1.111e-07 3.3 1.14e-07 3.3 1.141e-07 3.3 1.17e-07 3.3 1.171e-07 0 1.2e-07 0 1.2e-07 0 1.23e-07 0 1.231e-07 3.3 1.26e-07 3.3 1.26e-07 3.3 1.29e-07 3.3 1.291e-07 0 1.32e-07 0 1.32e-07 0 1.35e-07 0 1.351e-07 3.3 1.38e-07 3.3 1.38e-07 3.3 1.41e-07 3.3 1.411e-07 0 1.44e-07 0 1.44e-07 0 1.47e-07 0 1.471e-07 3.3 1.5e-07 3.3 1.5e-07 3.3 1.53e-07 3.3 1.531e-07 0 1.56e-07 0 1.56e-07 0 1.59e-07 0 1.591e-07 3.3 1.62e-07 3.3 1.62e-07 3.3 1.65e-07 3.3 1.651e-07 0 1.68e-07 0 1.68e-07 0 1.71e-07 0 1.711e-07 3.3 1.74e-07 3.3 1.741e-07 3.3 1.77e-07 3.3 1.771e-07 0 1.8e-07 0 1.801e-07 0 1.83e-07 0 1.831e-07 3.3 1.86e-07 3.3 1.861e-07 3.3 1.89e-07 3.3 1.891e-07 0 1.92e-07 0 1.921e-07 0 1.95e-07 0 1.95e-07 3.3 1.98e-07 3.3 1.981e-07 3.3 2.01e-07 3.3 2.01e-07 0 2.04e-07 0 2.041e-07 0 2.07e-07 0 2.07e-07 3.3 2.1e-07 3.3 2.101e-07 3.3 2.13e-07 3.3 2.13e-07 0 2.16e-07 0 2.161e-07 0 2.19e-07 0 2.19e-07 3.3 2.22e-07 3.3 2.221e-07 3.3 2.25e-07 3.3 2.25e-07 0 2.28e-07 0 2.281e-07 0 2.31e-07 0 2.31e-07 3.3 2.34e-07 3.3 2.341e-07 3.3 2.37e-07 3.3 2.37e-07 0 2.4e-07 0 2.4e-07 0 2.43e-07 0 2.43e-07 3.3 2.46e-07 3.3 2.461e-07 3.3 2.49e-07 3.3 2.491e-07 0 2.52e-07 0 2.52e-07 0 2.55e-07 0 2.55e-07 3.3 2.58e-07 3.3 2.581e-07 3.3 2.61e-07 3.3 2.611e-07 0 2.64e-07 0 2.64e-07 0 2.67e-07 0 2.67e-07 3.3 2.7e-07 3.3 2.701e-07 3.3 2.73e-07 3.3 2.731e-07 0 2.76e-07 0 2.76e-07 0 2.79e-07 0 2.791e-07 3.3 2.82e-07 3.3 2.821e-07 3.3 2.85e-07 3.3 2.851e-07 0 2.88e-07 0 2.88e-07 0 2.91e-07 0 2.911e-07 3.3 2.94e-07 3.3 2.941e-07 3.3 2.97e-07 3.3 2.97e-07 0 3e-07 0 3e-07 0 3.03e-07 0 3.031e-07 3.3 3.06e-07 3.3 3.061e-07 3.3 3.09e-07 3.3 3.09e-07 0 3.12e-07 0 3.12e-07 0 3.15e-07 0 3.151e-07 3.3 3.18e-07 3.3 3.181e-07 3.3 3.21e-07 3.3 3.21e-07 0 3.24e-07 0 3.24e-07 0 3.27e-07 0 3.271e-07 3.3 3.3e-07 3.3 3.301e-07 3.3 3.33e-07 3.3 3.33e-07 0 3.36e-07 0 3.36e-07 0 3.39e-07 0 3.391e-07 3.3 3.42e-07 3.3 3.421e-07 3.3 3.45e-07 3.3 3.45e-07 0 3.48e-07 0 3.48e-07 0 3.51e-07 0 3.511e-07 3.3 3.54e-07 3.3 3.541e-07 3.3 3.57e-07 3.3 3.57e-07 0 3.6e-07 0 3.6e-07 0 3.63e-07 0 3.631e-07 3.3 3.66e-07 3.3 3.661e-07 3.3 3.69e-07 3.3 3.69e-07 0 3.72e-07 0 3.72e-07 0 3.75e-07 0 3.751e-07 3.3 3.78e-07 3.3 3.781e-07 3.3 3.81e-07 3.3 3.81e-07 0 3.84e-07 0 3.841e-07 0 3.87e-07 0 3.871e-07 3.3 3.9e-07 3.3 3.9e-07 3.3 3.93e-07 3.3 3.93e-07 0 3.96e-07 0 3.961e-07 0 3.99e-07 0 3.991e-07 3.3 4.02e-07 3.3 4.02e-07 3.3 4.05e-07 3.3 4.05e-07 0 4.08e-07 0 4.081e-07 0 4.11e-07 0 4.111e-07 3.3 4.14e-07 3.3 4.14e-07 3.3 4.17e-07 3.3 4.17e-07 0 4.2e-07 0 4.201e-07 0 4.23e-07 0 4.231e-07 3.3 4.26e-07 3.3 4.26e-07 3.3 4.29e-07 3.3 4.29e-07 0 4.32e-07 0 4.321e-07 0 4.35e-07 0 4.351e-07 3.3 4.38e-07 3.3 4.38e-07 3.3 4.41e-07 3.3 4.41e-07 0 4.44e-07 0 4.441e-07 0 4.47e-07 0 4.471e-07 3.3 4.5e-07 3.3 4.5e-07 3.3 4.53e-07 3.3 4.53e-07 0 4.56e-07 0 4.561e-07 0 4.59e-07 0 4.591e-07 3.3 4.62e-07 3.3 4.62e-07 3.3 4.65e-07 3.3 4.65e-07 0 4.68e-07 0 4.681e-07 0 4.71e-07 0 4.711e-07 3.3 4.74e-07 3.3 4.74e-07 3.3 4.77e-07 3.3 4.771e-07 0 4.8e-07 0 4.8e-07 0 4.83e-07 0 4.83e-07 3.3 4.86e-07 3.3 4.86e-07 3.3 4.89e-07 3.3 4.891e-07 0 4.92e-07 0 4.921e-07 0 4.95e-07 0 4.951e-07 3.3 4.98e-07 3.3 4.981e-07 3.3 5.01e-07 3.3 5.01e-07 0 5.04e-07 0 5.04e-07 0 5.07e-07 0 5.07e-07 3.3 5.1e-07 3.3 5.1e-07 3.3 5.13e-07 3.3 5.131e-07 0 5.16e-07 0 5.161e-07 0 5.19e-07 0 5.191e-07 3.3 5.22e-07 3.3 5.221e-07 3.3 5.25e-07 3.3 5.25e-07 0 5.28e-07 0 5.28e-07 0 5.31e-07 0 5.31e-07 3.3 5.34e-07 3.3 5.34e-07 3.3 5.37e-07 3.3 5.371e-07 0 5.4e-07 0 5.401e-07 0 5.43e-07 0 5.431e-07 3.3 5.46e-07 3.3 5.461e-07 3.3 5.49e-07 3.3 5.49e-07 0 5.52e-07 0 5.52e-07 0 5.55e-07 0 5.55e-07 3.3 5.58e-07 3.3 5.58e-07 3.3 5.61e-07 3.3 5.611e-07 0 5.64e-07 0 5.641e-07 0 5.67e-07 0 5.671e-07 3.3 5.7e-07 3.3 5.701e-07 3.3 5.73e-07 3.3 5.73e-07 0 5.76e-07 0 5.76e-07 0 5.79e-07 0 5.79e-07 3.3 5.82e-07 3.3 5.821e-07 3.3 5.85e-07 3.3 5.851e-07 0 5.88e-07 0 5.881e-07 0 5.91e-07 0 5.911e-07 3.3 5.94e-07 3.3 5.94e-07 3.3 5.97e-07 3.3 5.97e-07 0 6e-07 0 6e-07 0 6.03e-07 0 6.03e-07 3.3 6.06e-07 3.3 6.061e-07 3.3 6.09e-07 3.3 6.091e-07 0 6.12e-07 0 6.121e-07 0 6.15e-07 0 6.151e-07 3.3 6.18e-07 3.3 6.18e-07 3.3 6.21e-07 3.3 6.21e-07 0 6.24e-07 0 6.24e-07 0 6.27e-07 0 6.27e-07 3.3 6.3e-07 3.3 6.301e-07 3.3 6.33e-07 3.3 6.331e-07 0 6.36e-07 0 6.361e-07 0 6.39e-07 0 6.391e-07 3.3 6.42e-07 3.3 6.42e-07 3.3 6.45e-07 3.3 6.45e-07 0 6.48e-07 0 6.48e-07 0 6.51e-07 0 6.51e-07 3.3 6.54e-07 3.3 6.541e-07 3.3 6.57e-07 3.3 6.571e-07 0 6.6e-07 0 6.601e-07 0 6.63e-07 0 6.631e-07 3.3 6.66e-07 3.3 6.66e-07 3.3 6.69e-07 3.3 6.69e-07 0 6.72e-07 0 6.72e-07 0 6.75e-07 0 6.75e-07 3.3 6.78e-07 3.3 6.781e-07 3.3 6.81e-07 3.3 6.811e-07 0 6.84e-07 0 6.841e-07 0 6.87e-07 0 6.87e-07 3.3 6.9e-07 3.3 6.9e-07 3.3 6.93e-07 3.3 6.93e-07 0 6.96e-07 0 6.96e-07 0 6.99e-07 0 6.991e-07 3.3 7.02e-07 3.3 7.021e-07 3.3 7.05e-07 3.3 7.051e-07 0 7.08e-07 0 7.081e-07 0 7.11e-07 0 7.11e-07 3.3 7.14e-07 3.3 7.14e-07 3.3 7.17e-07 3.3 7.17e-07 0 7.2e-07 0 7.2e-07 0 7.23e-07 0 7.231e-07 3.3 7.26e-07 3.3 7.261e-07 3.3 7.29e-07 3.3 7.291e-07 0 7.32e-07 0 7.321e-07 0 7.35e-07 0 7.35e-07 3.3 7.38e-07 3.3 7.38e-07 3.3 7.41e-07 3.3 7.41e-07 0 7.44e-07 0 7.44e-07 0 7.47e-07 0 7.471e-07 3.3 7.5e-07 3.3 7.501e-07 3.3 7.53e-07 3.3 7.531e-07 0 7.56e-07 0 7.561e-07 0 7.59e-07 0 7.59e-07 3.3 7.62e-07 3.3 7.62e-07 3.3 7.65e-07 3.3 7.65e-07 0 7.68e-07 0 7.68e-07 0 7.71e-07 0 7.711e-07 3.3 7.74e-07 3.3 7.741e-07 3.3 7.77e-07 3.3 7.771e-07 0 7.8e-07 0 7.8e-07 0 7.83e-07 0 7.83e-07 3.3 7.86e-07 3.3 7.86e-07 3.3 7.89e-07 3.3 7.89e-07 0 7.92e-07 0 7.921e-07 0 7.95e-07 0 7.951e-07 3.3 7.98e-07 3.3 7.981e-07 3.3 8.01e-07 3.3 8.011e-07 0 8.04e-07 0 8.04e-07 0 8.07e-07 0 8.07e-07 3.3 8.1e-07 3.3 8.1e-07 3.3 8.13e-07 3.3 8.13e-07 0 8.16e-07 0 8.161e-07 0 8.19e-07 0 8.191e-07 3.3 8.22e-07 3.3 8.221e-07 3.3 8.25e-07 3.3 8.251e-07 0 8.28e-07 0 8.28e-07 0 8.31e-07 0 8.31e-07 3.3 8.34e-07 3.3 8.34e-07 3.3 8.37e-07 3.3 8.37e-07 0 8.4e-07 0 8.401e-07 0 8.43e-07 0 8.431e-07 3.3 8.46e-07 3.3 8.461e-07 3.3 8.49e-07 3.3 8.491e-07 0 8.52e-07 0 8.52e-07 0 8.55e-07 0 8.55e-07 3.3 8.58e-07 3.3 8.58e-07 3.3 8.61e-07 3.3 8.61e-07 0 8.64e-07 0 8.641e-07 0 8.67e-07 0 8.671e-07 3.3 8.7e-07 3.3 8.701e-07 3.3 8.73e-07 3.3 8.73e-07 0 8.76e-07 0 8.76e-07 0 8.79e-07 0 8.79e-07 3.3 8.82e-07 3.3 8.82e-07 3.3 8.85e-07 3.3 8.851e-07 0 8.88e-07 0 8.881e-07 0 8.91e-07 0 8.911e-07 3.3 8.94e-07 3.3 8.941e-07 3.3 8.97e-07 3.3 8.97e-07 0 9e-07 0 9e-07 0 9.03e-07 0 9.03e-07 3.3 9.06e-07 3.3 9.06e-07 3.3 9.09e-07 3.3 9.091e-07 0 9.12e-07 0 9.121e-07 0 9.15e-07 0 9.151e-07 3.3 9.18e-07 3.3 9.181e-07 3.3 9.21e-07 3.3 9.21e-07 0 9.24e-07 0 9.24e-07 0 9.27e-07 0 9.27e-07 3.3 9.3e-07 3.3 9.3e-07 3.3 9.33e-07 3.3 9.331e-07 0 9.36e-07 0 9.361e-07 0 9.39e-07 0 9.391e-07 3.3 9.42e-07 3.3 9.421e-07 3.3 9.45e-07 3.3 9.45e-07 0 9.48e-07 0 9.48e-07 0 9.51e-07 0 9.51e-07 3.3 9.54e-07 3.3 9.54e-07 3.3 9.57e-07 3.3 9.57e-07 0 9.6e-07 0 9.6e-07 0 9.63e-07 0 9.63e-07 3.3 9.66e-07 3.3 9.66e-07 3.3 9.69e-07 3.3 9.69e-07 0 9.72e-07 0 9.72e-07 0 9.75e-07 0 9.75e-07 3.3 9.78e-07 3.3 9.78e-07 3.3 9.81e-07 3.3 9.81e-07 0 9.84e-07 0 9.84e-07 0 9.87e-07 0 9.87e-07 3.3 9.9e-07 3.3 9.9e-07 3.3 9.93e-07 3.3 9.93e-07 0 9.96e-07 0 9.96e-07 0 9.99e-07 0 9.99e-07 3.3 1.002e-06 3.3 1.002e-06 3.3 1.005e-06 3.3 1.005e-06 0 1.008e-06 0 1.008e-06 0 1.011e-06 0 1.011e-06 3.3 1.014e-06 3.3 1.014e-06 3.3 1.017e-06 3.3 1.017e-06 0 1.02e-06 0 1.02e-06 0 1.023e-06 0 1.023e-06 3.3 1.026e-06 3.3 1.026e-06 3.3 1.029e-06 3.3 1.029e-06 0 1.032e-06 0 1.032e-06 0 1.035e-06 0 1.035e-06 3.3 1.038e-06 3.3 1.038e-06 3.3 1.041e-06 3.3 1.041e-06 0 1.044e-06 0 1.044e-06 0 1.047e-06 0 1.047e-06 3.3 1.05e-06 3.3 1.05e-06 3.3 1.053e-06 3.3 1.053e-06 0 1.056e-06 0 1.056e-06 0 1.059e-06 0 1.059e-06 3.3 1.062e-06 3.3 1.062e-06 3.3 1.065e-06 3.3 1.065e-06 0 1.068e-06 0 1.068e-06 0 1.071e-06 0 1.071e-06 3.3 1.074e-06 3.3 1.074e-06 3.3 1.077e-06 3.3 1.077e-06 0 1.08e-06 0 1.08e-06 0 1.083e-06 0 1.083e-06 3.3 1.086e-06 3.3 1.086e-06 3.3 1.089e-06 3.3 1.089e-06 0 1.092e-06 0 1.092e-06 0 1.095e-06 0 1.095e-06 3.3 1.098e-06 3.3 1.098e-06 3.3 1.101e-06 3.3 1.101e-06 0 1.104e-06 0 1.104e-06 0 1.107e-06 0 1.107e-06 3.3 1.11e-06 3.3 1.11e-06 3.3 1.113e-06 3.3 1.113e-06 0 1.116e-06 0 1.116e-06 0 1.119e-06 0 1.119e-06 3.3 1.122e-06 3.3 1.122e-06 3.3 1.125e-06 3.3 1.125e-06 0 1.128e-06 0 1.128e-06 0 1.131e-06 0 1.131e-06 3.3 1.134e-06 3.3 1.134e-06 3.3 1.137e-06 3.3 1.137e-06 0 1.14e-06 0 1.14e-06 0 1.143e-06 0 1.143e-06 3.3 1.146e-06 3.3 1.146e-06 3.3 1.149e-06 3.3 1.149e-06 0 1.152e-06 0 1.152e-06 0 1.155e-06 0 1.155e-06 3.3 1.158e-06 3.3 1.158e-06 3.3 1.161e-06 3.3 1.161e-06 0 1.164e-06 0 1.164e-06 0 1.167e-06 0 1.167e-06 3.3 1.17e-06 3.3 1.17e-06 3.3 1.173e-06 3.3 1.173e-06 0 1.176e-06 0 1.176e-06 0 1.179e-06 0 1.179e-06 3.3 1.182e-06 3.3 1.182e-06 3.3 1.185e-06 3.3 1.185e-06 0 1.188e-06 0 1.188e-06 0 1.191e-06 0 1.191e-06 3.3 1.194e-06 3.3 1.194e-06 3.3 1.197e-06 3.3 1.197e-06 0 1.2e-06 0 1.2e-06 0 1.203e-06 0 1.203e-06 3.3 1.206e-06 3.3 1.206e-06 3.3 1.209e-06 3.3 1.209e-06 0 1.212e-06 0 1.212e-06 0 1.215e-06 0 1.215e-06 3.3 1.218e-06 3.3 1.218e-06 3.3 1.221e-06 3.3 1.221e-06 0 1.224e-06 0 1.224e-06 0 1.227e-06 0 1.227e-06 3.3 1.23e-06 3.3 1.23e-06 3.3 1.233e-06 3.3 1.233e-06 0 1.236e-06 0 1.236e-06 0 1.239e-06 0 1.239e-06 3.3 1.242e-06 3.3 1.242e-06 3.3 1.245e-06 3.3 1.245e-06 0 1.248e-06 0 1.248e-06 0 1.251e-06 0 1.251e-06 3.3 1.254e-06 3.3 1.254e-06 3.3 1.257e-06 3.3 1.257e-06 0 1.26e-06 0 1.26e-06 0 1.263e-06 0 1.263e-06 3.3 1.266e-06 3.3 1.266e-06 3.3 1.269e-06 3.3 1.269e-06 0 1.272e-06 0 1.272e-06 0 1.275e-06 0 1.275e-06 3.3 1.278e-06 3.3 1.278e-06 3.3 1.281e-06 3.3 1.281e-06 0 1.284e-06 0 1.284e-06 0 1.287e-06 0 1.287e-06 3.3 1.29e-06 3.3 1.29e-06 3.3 1.293e-06 3.3 1.293e-06 0 1.296e-06 0 1.296e-06 0 1.299e-06 0 1.299e-06 3.3 1.302e-06 3.3 1.302e-06 3.3 1.305e-06 3.3 1.305e-06 0 1.308e-06 0 1.308e-06 0 1.311e-06 0 1.311e-06 3.3 1.314e-06 3.3 1.314e-06 3.3 1.317e-06 3.3 1.317e-06 0 1.32e-06 0 1.32e-06 0 1.323e-06 0 1.323e-06 3.3 1.326e-06 3.3 1.326e-06 3.3 1.329e-06 3.3 1.329e-06 0 1.332e-06 0 1.332e-06 0 1.335e-06 0 1.335e-06 3.3 1.338e-06 3.3 1.338e-06 3.3 1.341e-06 3.3 1.341e-06 0 1.344e-06 0 1.344e-06 0 1.347e-06 0 1.347e-06 3.3 1.35e-06 3.3 1.35e-06 3.3 1.353e-06 3.3 1.353e-06 0 1.356e-06 0 1.356e-06 0 1.359e-06 0 1.359e-06 3.3 1.362e-06 3.3 1.362e-06 3.3 1.365e-06 3.3 1.365e-06 0 1.368e-06 0 1.368e-06 0 1.371e-06 0 1.371e-06 3.3 1.374e-06 3.3 1.374e-06 3.3 1.377e-06 3.3 1.377e-06 0 1.38e-06 0 1.38e-06 0 1.383e-06 0 1.383e-06 3.3 1.386e-06 3.3 1.386e-06 3.3 1.389e-06 3.3 1.389e-06 0 1.392e-06 0 1.392e-06 0 1.395e-06 0 1.395e-06 3.3 1.398e-06 3.3 1.398e-06 3.3 1.401e-06 3.3 1.401e-06 0 1.404e-06 0 1.404e-06 0 1.407e-06 0 1.407e-06 3.3 1.41e-06 3.3 1.41e-06 3.3 1.413e-06 3.3 1.413e-06 0 1.416e-06 0 1.416e-06 0 1.419e-06 0 1.419e-06 3.3 1.422e-06 3.3 1.422e-06 3.3 1.425e-06 3.3 1.425e-06 0 1.428e-06 0 1.428e-06 0 1.431e-06 0 1.431e-06 3.3 1.434e-06 3.3 1.434e-06 3.3 1.437e-06 3.3 1.437e-06 0 1.44e-06 0 1.44e-06 0 1.443e-06 0 1.443e-06 3.3 1.446e-06 3.3 1.446e-06 3.3 1.449e-06 3.3 1.449e-06 0 1.452e-06 0 1.452e-06 0 1.455e-06 0 1.455e-06 3.3 1.458e-06 3.3 1.458e-06 3.3 1.461e-06 3.3 1.461e-06 0 1.464e-06 0 1.464e-06 0 1.467e-06 0 1.467e-06 3.3 1.47e-06 3.3 1.47e-06 3.3 1.473e-06 3.3 1.473e-06 0 1.476e-06 0 1.476e-06 0 1.479e-06 0 1.479e-06 3.3 1.482e-06 3.3 1.482e-06 3.3 1.485e-06 3.3 1.485e-06 0 1.488e-06 0 1.488e-06 0 1.491e-06 0 1.491e-06 3.3 1.494e-06 3.3 1.494e-06 3.3 1.497e-06 3.3 1.497e-06 0 1.5e-06 0 1.5e-06 0 1.503e-06 0 1.503e-06 3.3 1.506e-06 3.3 1.506e-06 3.3 1.509e-06 3.3 1.509e-06 0 1.512e-06 0 1.512e-06 0 1.515e-06 0 1.515e-06 3.3 1.518e-06 3.3 1.518e-06 3.3 1.521e-06 3.3 1.521e-06 0 1.524e-06 0 1.524e-06 0 1.527e-06 0 1.527e-06 3.3 1.53e-06 3.3 1.53e-06 3.3 1.533e-06 3.3 1.533e-06 0)
VA1 A1 0 PWL(0 0 3e-09 0 3.05e-09 0 6e-09 0 6.05e-09 3.3 9e-09 3.3 9.05e-09 3.3 1.2e-08 3.3 1.205e-08 3.3 1.5e-08 3.3 1.505e-08 3.3 1.8e-08 3.3 1.805e-08 0 2.1e-08 0 2.105e-08 0 2.4e-08 0 2.405e-08 0 2.7e-08 0 2.705e-08 0 3e-08 0 3.005e-08 3.3 3.3e-08 3.3 3.305e-08 3.3 3.6e-08 3.3 3.605e-08 3.3 3.9e-08 3.3 3.905e-08 3.3 4.2e-08 3.3 4.205e-08 0 4.5e-08 0 4.505e-08 0 4.8e-08 0 4.805e-08 0 5.1e-08 0 5.105e-08 0 5.4e-08 0 5.405e-08 3.3 5.7e-08 3.3 5.705e-08 3.3 6e-08 3.3 6.005e-08 3.3 6.3e-08 3.3 6.305e-08 3.3 6.6e-08 3.3 6.605e-08 0 6.9e-08 0 6.905e-08 0 7.2e-08 0 7.205e-08 0 7.5e-08 0 7.505e-08 0 7.8e-08 0 7.805e-08 3.3 8.1e-08 3.3 8.105e-08 3.3 8.4e-08 3.3 8.405e-08 3.3 8.7e-08 3.3 8.705e-08 3.3 9e-08 3.3 9.005e-08 0 9.3e-08 0 9.305e-08 0 9.6e-08 0 9.605e-08 0 9.9e-08 0 9.905e-08 0 1.02e-07 0 1.021e-07 3.3 1.05e-07 3.3 1.051e-07 3.3 1.08e-07 3.3 1.081e-07 3.3 1.11e-07 3.3 1.111e-07 3.3 1.14e-07 3.3 1.141e-07 0 1.17e-07 0 1.171e-07 0 1.2e-07 0 1.2e-07 0 1.23e-07 0 1.231e-07 0 1.26e-07 0 1.26e-07 3.3 1.29e-07 3.3 1.291e-07 3.3 1.32e-07 3.3 1.32e-07 3.3 1.35e-07 3.3 1.351e-07 3.3 1.38e-07 3.3 1.38e-07 0 1.41e-07 0 1.411e-07 0 1.44e-07 0 1.44e-07 0 1.47e-07 0 1.471e-07 0 1.5e-07 0 1.5e-07 3.3 1.53e-07 3.3 1.531e-07 3.3 1.56e-07 3.3 1.56e-07 3.3 1.59e-07 3.3 1.591e-07 3.3 1.62e-07 3.3 1.62e-07 0 1.65e-07 0 1.651e-07 0 1.68e-07 0 1.68e-07 0 1.71e-07 0 1.711e-07 0 1.74e-07 0 1.741e-07 3.3 1.77e-07 3.3 1.771e-07 3.3 1.8e-07 3.3 1.801e-07 3.3 1.83e-07 3.3 1.831e-07 3.3 1.86e-07 3.3 1.861e-07 0 1.89e-07 0 1.891e-07 0 1.92e-07 0 1.921e-07 0 1.95e-07 0 1.95e-07 0 1.98e-07 0 1.981e-07 3.3 2.01e-07 3.3 2.01e-07 3.3 2.04e-07 3.3 2.041e-07 3.3 2.07e-07 3.3 2.07e-07 3.3 2.1e-07 3.3 2.101e-07 0 2.13e-07 0 2.13e-07 0 2.16e-07 0 2.161e-07 0 2.19e-07 0 2.19e-07 0 2.22e-07 0 2.221e-07 3.3 2.25e-07 3.3 2.25e-07 3.3 2.28e-07 3.3 2.281e-07 3.3 2.31e-07 3.3 2.31e-07 3.3 2.34e-07 3.3 2.341e-07 0 2.37e-07 0 2.37e-07 0 2.4e-07 0 2.4e-07 0 2.43e-07 0 2.43e-07 0 2.46e-07 0 2.461e-07 3.3 2.49e-07 3.3 2.491e-07 3.3 2.52e-07 3.3 2.52e-07 3.3 2.55e-07 3.3 2.55e-07 3.3 2.58e-07 3.3 2.581e-07 0 2.61e-07 0 2.611e-07 0 2.64e-07 0 2.64e-07 0 2.67e-07 0 2.67e-07 0 2.7e-07 0 2.701e-07 3.3 2.73e-07 3.3 2.731e-07 3.3 2.76e-07 3.3 2.76e-07 3.3 2.79e-07 3.3 2.791e-07 3.3 2.82e-07 3.3 2.821e-07 0 2.85e-07 0 2.851e-07 0 2.88e-07 0 2.88e-07 0 2.91e-07 0 2.911e-07 0 2.94e-07 0 2.941e-07 3.3 2.97e-07 3.3 2.97e-07 3.3 3e-07 3.3 3e-07 3.3 3.03e-07 3.3 3.031e-07 3.3 3.06e-07 3.3 3.061e-07 0 3.09e-07 0 3.09e-07 0 3.12e-07 0 3.12e-07 0 3.15e-07 0 3.151e-07 0 3.18e-07 0 3.181e-07 3.3 3.21e-07 3.3 3.21e-07 3.3 3.24e-07 3.3 3.24e-07 3.3 3.27e-07 3.3 3.271e-07 3.3 3.3e-07 3.3 3.301e-07 0 3.33e-07 0 3.33e-07 0 3.36e-07 0 3.36e-07 0 3.39e-07 0 3.391e-07 0 3.42e-07 0 3.421e-07 3.3 3.45e-07 3.3 3.45e-07 3.3 3.48e-07 3.3 3.48e-07 3.3 3.51e-07 3.3 3.511e-07 3.3 3.54e-07 3.3 3.541e-07 0 3.57e-07 0 3.57e-07 0 3.6e-07 0 3.6e-07 0 3.63e-07 0 3.631e-07 0 3.66e-07 0 3.661e-07 3.3 3.69e-07 3.3 3.69e-07 3.3 3.72e-07 3.3 3.72e-07 3.3 3.75e-07 3.3 3.751e-07 3.3 3.78e-07 3.3 3.781e-07 0 3.81e-07 0 3.81e-07 0 3.84e-07 0 3.841e-07 0 3.87e-07 0 3.871e-07 0 3.9e-07 0 3.9e-07 3.3 3.93e-07 3.3 3.93e-07 3.3 3.96e-07 3.3 3.961e-07 3.3 3.99e-07 3.3 3.991e-07 3.3 4.02e-07 3.3 4.02e-07 0 4.05e-07 0 4.05e-07 0 4.08e-07 0 4.081e-07 0 4.11e-07 0 4.111e-07 0 4.14e-07 0 4.14e-07 3.3 4.17e-07 3.3 4.17e-07 3.3 4.2e-07 3.3 4.201e-07 3.3 4.23e-07 3.3 4.231e-07 3.3 4.26e-07 3.3 4.26e-07 0 4.29e-07 0 4.29e-07 0 4.32e-07 0 4.321e-07 0 4.35e-07 0 4.351e-07 0 4.38e-07 0 4.38e-07 3.3 4.41e-07 3.3 4.41e-07 3.3 4.44e-07 3.3 4.441e-07 3.3 4.47e-07 3.3 4.471e-07 3.3 4.5e-07 3.3 4.5e-07 0 4.53e-07 0 4.53e-07 0 4.56e-07 0 4.561e-07 0 4.59e-07 0 4.591e-07 0 4.62e-07 0 4.62e-07 3.3 4.65e-07 3.3 4.65e-07 3.3 4.68e-07 3.3 4.681e-07 3.3 4.71e-07 3.3 4.711e-07 3.3 4.74e-07 3.3 4.74e-07 0 4.77e-07 0 4.771e-07 0 4.8e-07 0 4.8e-07 0 4.83e-07 0 4.83e-07 0 4.86e-07 0 4.86e-07 3.3 4.89e-07 3.3 4.891e-07 3.3 4.92e-07 3.3 4.921e-07 3.3 4.95e-07 3.3 4.951e-07 3.3 4.98e-07 3.3 4.981e-07 0 5.01e-07 0 5.01e-07 0 5.04e-07 0 5.04e-07 0 5.07e-07 0 5.07e-07 0 5.1e-07 0 5.1e-07 3.3 5.13e-07 3.3 5.131e-07 3.3 5.16e-07 3.3 5.161e-07 3.3 5.19e-07 3.3 5.191e-07 3.3 5.22e-07 3.3 5.221e-07 0 5.25e-07 0 5.25e-07 0 5.28e-07 0 5.28e-07 0 5.31e-07 0 5.31e-07 0 5.34e-07 0 5.34e-07 3.3 5.37e-07 3.3 5.371e-07 3.3 5.4e-07 3.3 5.401e-07 3.3 5.43e-07 3.3 5.431e-07 3.3 5.46e-07 3.3 5.461e-07 0 5.49e-07 0 5.49e-07 0 5.52e-07 0 5.52e-07 0 5.55e-07 0 5.55e-07 0 5.58e-07 0 5.58e-07 3.3 5.61e-07 3.3 5.611e-07 3.3 5.64e-07 3.3 5.641e-07 3.3 5.67e-07 3.3 5.671e-07 3.3 5.7e-07 3.3 5.701e-07 0 5.73e-07 0 5.73e-07 0 5.76e-07 0 5.76e-07 0 5.79e-07 0 5.79e-07 0 5.82e-07 0 5.821e-07 3.3 5.85e-07 3.3 5.851e-07 3.3 5.88e-07 3.3 5.881e-07 3.3 5.91e-07 3.3 5.911e-07 3.3 5.94e-07 3.3 5.94e-07 0 5.97e-07 0 5.97e-07 0 6e-07 0 6e-07 0 6.03e-07 0 6.03e-07 0 6.06e-07 0 6.061e-07 3.3 6.09e-07 3.3 6.091e-07 3.3 6.12e-07 3.3 6.121e-07 3.3 6.15e-07 3.3 6.151e-07 3.3 6.18e-07 3.3 6.18e-07 0 6.21e-07 0 6.21e-07 0 6.24e-07 0 6.24e-07 0 6.27e-07 0 6.27e-07 0 6.3e-07 0 6.301e-07 3.3 6.33e-07 3.3 6.331e-07 3.3 6.36e-07 3.3 6.361e-07 3.3 6.39e-07 3.3 6.391e-07 3.3 6.42e-07 3.3 6.42e-07 0 6.45e-07 0 6.45e-07 0 6.48e-07 0 6.48e-07 0 6.51e-07 0 6.51e-07 0 6.54e-07 0 6.541e-07 3.3 6.57e-07 3.3 6.571e-07 3.3 6.6e-07 3.3 6.601e-07 3.3 6.63e-07 3.3 6.631e-07 3.3 6.66e-07 3.3 6.66e-07 0 6.69e-07 0 6.69e-07 0 6.72e-07 0 6.72e-07 0 6.75e-07 0 6.75e-07 0 6.78e-07 0 6.781e-07 3.3 6.81e-07 3.3 6.811e-07 3.3 6.84e-07 3.3 6.841e-07 3.3 6.87e-07 3.3 6.87e-07 3.3 6.9e-07 3.3 6.9e-07 0 6.93e-07 0 6.93e-07 0 6.96e-07 0 6.96e-07 0 6.99e-07 0 6.991e-07 0 7.02e-07 0 7.021e-07 3.3 7.05e-07 3.3 7.051e-07 3.3 7.08e-07 3.3 7.081e-07 3.3 7.11e-07 3.3 7.11e-07 3.3 7.14e-07 3.3 7.14e-07 0 7.17e-07 0 7.17e-07 0 7.2e-07 0 7.2e-07 0 7.23e-07 0 7.231e-07 0 7.26e-07 0 7.261e-07 3.3 7.29e-07 3.3 7.291e-07 3.3 7.32e-07 3.3 7.321e-07 3.3 7.35e-07 3.3 7.35e-07 3.3 7.38e-07 3.3 7.38e-07 0 7.41e-07 0 7.41e-07 0 7.44e-07 0 7.44e-07 0 7.47e-07 0 7.471e-07 0 7.5e-07 0 7.501e-07 3.3 7.53e-07 3.3 7.531e-07 3.3 7.56e-07 3.3 7.561e-07 3.3 7.59e-07 3.3 7.59e-07 3.3 7.62e-07 3.3 7.62e-07 0 7.65e-07 0 7.65e-07 0 7.68e-07 0 7.68e-07 0 7.71e-07 0 7.711e-07 0 7.74e-07 0 7.741e-07 3.3 7.77e-07 3.3 7.771e-07 3.3 7.8e-07 3.3 7.8e-07 3.3 7.83e-07 3.3 7.83e-07 3.3 7.86e-07 3.3 7.86e-07 0 7.89e-07 0 7.89e-07 0 7.92e-07 0 7.921e-07 0 7.95e-07 0 7.951e-07 0 7.98e-07 0 7.981e-07 3.3 8.01e-07 3.3 8.011e-07 3.3 8.04e-07 3.3 8.04e-07 3.3 8.07e-07 3.3 8.07e-07 3.3 8.1e-07 3.3 8.1e-07 0 8.13e-07 0 8.13e-07 0 8.16e-07 0 8.161e-07 0 8.19e-07 0 8.191e-07 0 8.22e-07 0 8.221e-07 3.3 8.25e-07 3.3 8.251e-07 3.3 8.28e-07 3.3 8.28e-07 3.3 8.31e-07 3.3 8.31e-07 3.3 8.34e-07 3.3 8.34e-07 0 8.37e-07 0 8.37e-07 0 8.4e-07 0 8.401e-07 0 8.43e-07 0 8.431e-07 0 8.46e-07 0 8.461e-07 3.3 8.49e-07 3.3 8.491e-07 3.3 8.52e-07 3.3 8.52e-07 3.3 8.55e-07 3.3 8.55e-07 3.3 8.58e-07 3.3 8.58e-07 0 8.61e-07 0 8.61e-07 0 8.64e-07 0 8.641e-07 0 8.67e-07 0 8.671e-07 0 8.7e-07 0 8.701e-07 3.3 8.73e-07 3.3 8.73e-07 3.3 8.76e-07 3.3 8.76e-07 3.3 8.79e-07 3.3 8.79e-07 3.3 8.82e-07 3.3 8.82e-07 0 8.85e-07 0 8.851e-07 0 8.88e-07 0 8.881e-07 0 8.91e-07 0 8.911e-07 0 8.94e-07 0 8.941e-07 3.3 8.97e-07 3.3 8.97e-07 3.3 9e-07 3.3 9e-07 3.3 9.03e-07 3.3 9.03e-07 3.3 9.06e-07 3.3 9.06e-07 0 9.09e-07 0 9.091e-07 0 9.12e-07 0 9.121e-07 0 9.15e-07 0 9.151e-07 0 9.18e-07 0 9.181e-07 3.3 9.21e-07 3.3 9.21e-07 3.3 9.24e-07 3.3 9.24e-07 3.3 9.27e-07 3.3 9.27e-07 3.3 9.3e-07 3.3 9.3e-07 0 9.33e-07 0 9.331e-07 0 9.36e-07 0 9.361e-07 0 9.39e-07 0 9.391e-07 0 9.42e-07 0 9.421e-07 3.3 9.45e-07 3.3 9.45e-07 3.3 9.48e-07 3.3 9.48e-07 3.3 9.51e-07 3.3 9.51e-07 3.3 9.54e-07 3.3 9.54e-07 0 9.57e-07 0 9.57e-07 0 9.6e-07 0 9.6e-07 0 9.63e-07 0 9.63e-07 0 9.66e-07 0 9.66e-07 3.3 9.69e-07 3.3 9.69e-07 3.3 9.72e-07 3.3 9.72e-07 3.3 9.75e-07 3.3 9.75e-07 3.3 9.78e-07 3.3 9.78e-07 0 9.81e-07 0 9.81e-07 0 9.84e-07 0 9.84e-07 0 9.87e-07 0 9.87e-07 0 9.9e-07 0 9.9e-07 3.3 9.93e-07 3.3 9.93e-07 3.3 9.96e-07 3.3 9.96e-07 3.3 9.99e-07 3.3 9.99e-07 3.3 1.002e-06 3.3 1.002e-06 0 1.005e-06 0 1.005e-06 0 1.008e-06 0 1.008e-06 0 1.011e-06 0 1.011e-06 0 1.014e-06 0 1.014e-06 3.3 1.017e-06 3.3 1.017e-06 3.3 1.02e-06 3.3 1.02e-06 3.3 1.023e-06 3.3 1.023e-06 3.3 1.026e-06 3.3 1.026e-06 0 1.029e-06 0 1.029e-06 0 1.032e-06 0 1.032e-06 0 1.035e-06 0 1.035e-06 0 1.038e-06 0 1.038e-06 3.3 1.041e-06 3.3 1.041e-06 3.3 1.044e-06 3.3 1.044e-06 3.3 1.047e-06 3.3 1.047e-06 3.3 1.05e-06 3.3 1.05e-06 0 1.053e-06 0 1.053e-06 0 1.056e-06 0 1.056e-06 0 1.059e-06 0 1.059e-06 0 1.062e-06 0 1.062e-06 3.3 1.065e-06 3.3 1.065e-06 3.3 1.068e-06 3.3 1.068e-06 3.3 1.071e-06 3.3 1.071e-06 3.3 1.074e-06 3.3 1.074e-06 0 1.077e-06 0 1.077e-06 0 1.08e-06 0 1.08e-06 0 1.083e-06 0 1.083e-06 0 1.086e-06 0 1.086e-06 3.3 1.089e-06 3.3 1.089e-06 3.3 1.092e-06 3.3 1.092e-06 3.3 1.095e-06 3.3 1.095e-06 3.3 1.098e-06 3.3 1.098e-06 0 1.101e-06 0 1.101e-06 0 1.104e-06 0 1.104e-06 0 1.107e-06 0 1.107e-06 0 1.11e-06 0 1.11e-06 3.3 1.113e-06 3.3 1.113e-06 3.3 1.116e-06 3.3 1.116e-06 3.3 1.119e-06 3.3 1.119e-06 3.3 1.122e-06 3.3 1.122e-06 0 1.125e-06 0 1.125e-06 0 1.128e-06 0 1.128e-06 0 1.131e-06 0 1.131e-06 0 1.134e-06 0 1.134e-06 3.3 1.137e-06 3.3 1.137e-06 3.3 1.14e-06 3.3 1.14e-06 3.3 1.143e-06 3.3 1.143e-06 3.3 1.146e-06 3.3 1.146e-06 0 1.149e-06 0 1.149e-06 0 1.152e-06 0 1.152e-06 0 1.155e-06 0 1.155e-06 0 1.158e-06 0 1.158e-06 3.3 1.161e-06 3.3 1.161e-06 3.3 1.164e-06 3.3 1.164e-06 3.3 1.167e-06 3.3 1.167e-06 3.3 1.17e-06 3.3 1.17e-06 0 1.173e-06 0 1.173e-06 0 1.176e-06 0 1.176e-06 0 1.179e-06 0 1.179e-06 0 1.182e-06 0 1.182e-06 3.3 1.185e-06 3.3 1.185e-06 3.3 1.188e-06 3.3 1.188e-06 3.3 1.191e-06 3.3 1.191e-06 3.3 1.194e-06 3.3 1.194e-06 0 1.197e-06 0 1.197e-06 0 1.2e-06 0 1.2e-06 0 1.203e-06 0 1.203e-06 0 1.206e-06 0 1.206e-06 3.3 1.209e-06 3.3 1.209e-06 3.3 1.212e-06 3.3 1.212e-06 3.3 1.215e-06 3.3 1.215e-06 3.3 1.218e-06 3.3 1.218e-06 0 1.221e-06 0 1.221e-06 0 1.224e-06 0 1.224e-06 0 1.227e-06 0 1.227e-06 0 1.23e-06 0 1.23e-06 3.3 1.233e-06 3.3 1.233e-06 3.3 1.236e-06 3.3 1.236e-06 3.3 1.239e-06 3.3 1.239e-06 3.3 1.242e-06 3.3 1.242e-06 0 1.245e-06 0 1.245e-06 0 1.248e-06 0 1.248e-06 0 1.251e-06 0 1.251e-06 0 1.254e-06 0 1.254e-06 3.3 1.257e-06 3.3 1.257e-06 3.3 1.26e-06 3.3 1.26e-06 3.3 1.263e-06 3.3 1.263e-06 3.3 1.266e-06 3.3 1.266e-06 0 1.269e-06 0 1.269e-06 0 1.272e-06 0 1.272e-06 0 1.275e-06 0 1.275e-06 0 1.278e-06 0 1.278e-06 3.3 1.281e-06 3.3 1.281e-06 3.3 1.284e-06 3.3 1.284e-06 3.3 1.287e-06 3.3 1.287e-06 3.3 1.29e-06 3.3 1.29e-06 0 1.293e-06 0 1.293e-06 0 1.296e-06 0 1.296e-06 0 1.299e-06 0 1.299e-06 0 1.302e-06 0 1.302e-06 3.3 1.305e-06 3.3 1.305e-06 3.3 1.308e-06 3.3 1.308e-06 3.3 1.311e-06 3.3 1.311e-06 3.3 1.314e-06 3.3 1.314e-06 0 1.317e-06 0 1.317e-06 0 1.32e-06 0 1.32e-06 0 1.323e-06 0 1.323e-06 0 1.326e-06 0 1.326e-06 3.3 1.329e-06 3.3 1.329e-06 3.3 1.332e-06 3.3 1.332e-06 3.3 1.335e-06 3.3 1.335e-06 3.3 1.338e-06 3.3 1.338e-06 0 1.341e-06 0 1.341e-06 0 1.344e-06 0 1.344e-06 0 1.347e-06 0 1.347e-06 0 1.35e-06 0 1.35e-06 3.3 1.353e-06 3.3 1.353e-06 3.3 1.356e-06 3.3 1.356e-06 3.3 1.359e-06 3.3 1.359e-06 3.3 1.362e-06 3.3 1.362e-06 0 1.365e-06 0 1.365e-06 0 1.368e-06 0 1.368e-06 0 1.371e-06 0 1.371e-06 0 1.374e-06 0 1.374e-06 3.3 1.377e-06 3.3 1.377e-06 3.3 1.38e-06 3.3 1.38e-06 3.3 1.383e-06 3.3 1.383e-06 3.3 1.386e-06 3.3 1.386e-06 0 1.389e-06 0 1.389e-06 0 1.392e-06 0 1.392e-06 0 1.395e-06 0 1.395e-06 0 1.398e-06 0 1.398e-06 3.3 1.401e-06 3.3 1.401e-06 3.3 1.404e-06 3.3 1.404e-06 3.3 1.407e-06 3.3 1.407e-06 3.3 1.41e-06 3.3 1.41e-06 0 1.413e-06 0 1.413e-06 0 1.416e-06 0 1.416e-06 0 1.419e-06 0 1.419e-06 0 1.422e-06 0 1.422e-06 3.3 1.425e-06 3.3 1.425e-06 3.3 1.428e-06 3.3 1.428e-06 3.3 1.431e-06 3.3 1.431e-06 3.3 1.434e-06 3.3 1.434e-06 0 1.437e-06 0 1.437e-06 0 1.44e-06 0 1.44e-06 0 1.443e-06 0 1.443e-06 0 1.446e-06 0 1.446e-06 3.3 1.449e-06 3.3 1.449e-06 3.3 1.452e-06 3.3 1.452e-06 3.3 1.455e-06 3.3 1.455e-06 3.3 1.458e-06 3.3 1.458e-06 0 1.461e-06 0 1.461e-06 0 1.464e-06 0 1.464e-06 0 1.467e-06 0 1.467e-06 0 1.47e-06 0 1.47e-06 3.3 1.473e-06 3.3 1.473e-06 3.3 1.476e-06 3.3 1.476e-06 3.3 1.479e-06 3.3 1.479e-06 3.3 1.482e-06 3.3 1.482e-06 0 1.485e-06 0 1.485e-06 0 1.488e-06 0 1.488e-06 0 1.491e-06 0 1.491e-06 0 1.494e-06 0 1.494e-06 3.3 1.497e-06 3.3 1.497e-06 3.3 1.5e-06 3.3 1.5e-06 3.3 1.503e-06 3.3 1.503e-06 3.3 1.506e-06 3.3 1.506e-06 0 1.509e-06 0 1.509e-06 0 1.512e-06 0 1.512e-06 0 1.515e-06 0 1.515e-06 0 1.518e-06 0 1.518e-06 3.3 1.521e-06 3.3 1.521e-06 3.3 1.524e-06 3.3 1.524e-06 3.3 1.527e-06 3.3 1.527e-06 3.3 1.53e-06 3.3 1.53e-06 0 1.533e-06 0 1.533e-06 0)
VA2 A2 0 PWL(0 0 3e-09 0 3.05e-09 0 6e-09 0 6.05e-09 0 9e-09 0 9.05e-09 0 1.2e-08 0 1.205e-08 3.3 1.5e-08 3.3 1.505e-08 3.3 1.8e-08 3.3 1.805e-08 3.3 2.1e-08 3.3 2.105e-08 3.3 2.4e-08 3.3 2.405e-08 3.3 2.7e-08 3.3 2.705e-08 3.3 3e-08 3.3 3.005e-08 3.3 3.3e-08 3.3 3.305e-08 3.3 3.6e-08 3.3 3.605e-08 0 3.9e-08 0 3.905e-08 0 4.2e-08 0 4.205e-08 0 4.5e-08 0 4.505e-08 0 4.8e-08 0 4.805e-08 0 5.1e-08 0 5.105e-08 0 5.4e-08 0 5.405e-08 0 5.7e-08 0 5.705e-08 0 6e-08 0 6.005e-08 3.3 6.3e-08 3.3 6.305e-08 3.3 6.6e-08 3.3 6.605e-08 3.3 6.9e-08 3.3 6.905e-08 3.3 7.2e-08 3.3 7.205e-08 3.3 7.5e-08 3.3 7.505e-08 3.3 7.8e-08 3.3 7.805e-08 3.3 8.1e-08 3.3 8.105e-08 3.3 8.4e-08 3.3 8.405e-08 0 8.7e-08 0 8.705e-08 0 9e-08 0 9.005e-08 0 9.3e-08 0 9.305e-08 0 9.6e-08 0 9.605e-08 0 9.9e-08 0 9.905e-08 0 1.02e-07 0 1.021e-07 0 1.05e-07 0 1.051e-07 0 1.08e-07 0 1.081e-07 3.3 1.11e-07 3.3 1.111e-07 3.3 1.14e-07 3.3 1.141e-07 3.3 1.17e-07 3.3 1.171e-07 3.3 1.2e-07 3.3 1.2e-07 3.3 1.23e-07 3.3 1.231e-07 3.3 1.26e-07 3.3 1.26e-07 3.3 1.29e-07 3.3 1.291e-07 3.3 1.32e-07 3.3 1.32e-07 0 1.35e-07 0 1.351e-07 0 1.38e-07 0 1.38e-07 0 1.41e-07 0 1.411e-07 0 1.44e-07 0 1.44e-07 0 1.47e-07 0 1.471e-07 0 1.5e-07 0 1.5e-07 0 1.53e-07 0 1.531e-07 0 1.56e-07 0 1.56e-07 3.3 1.59e-07 3.3 1.591e-07 3.3 1.62e-07 3.3 1.62e-07 3.3 1.65e-07 3.3 1.651e-07 3.3 1.68e-07 3.3 1.68e-07 3.3 1.71e-07 3.3 1.711e-07 3.3 1.74e-07 3.3 1.741e-07 3.3 1.77e-07 3.3 1.771e-07 3.3 1.8e-07 3.3 1.801e-07 0 1.83e-07 0 1.831e-07 0 1.86e-07 0 1.861e-07 0 1.89e-07 0 1.891e-07 0 1.92e-07 0 1.921e-07 0 1.95e-07 0 1.95e-07 0 1.98e-07 0 1.981e-07 0 2.01e-07 0 2.01e-07 0 2.04e-07 0 2.041e-07 3.3 2.07e-07 3.3 2.07e-07 3.3 2.1e-07 3.3 2.101e-07 3.3 2.13e-07 3.3 2.13e-07 3.3 2.16e-07 3.3 2.161e-07 3.3 2.19e-07 3.3 2.19e-07 3.3 2.22e-07 3.3 2.221e-07 3.3 2.25e-07 3.3 2.25e-07 3.3 2.28e-07 3.3 2.281e-07 0 2.31e-07 0 2.31e-07 0 2.34e-07 0 2.341e-07 0 2.37e-07 0 2.37e-07 0 2.4e-07 0 2.4e-07 0 2.43e-07 0 2.43e-07 0 2.46e-07 0 2.461e-07 0 2.49e-07 0 2.491e-07 0 2.52e-07 0 2.52e-07 3.3 2.55e-07 3.3 2.55e-07 3.3 2.58e-07 3.3 2.581e-07 3.3 2.61e-07 3.3 2.611e-07 3.3 2.64e-07 3.3 2.64e-07 3.3 2.67e-07 3.3 2.67e-07 3.3 2.7e-07 3.3 2.701e-07 3.3 2.73e-07 3.3 2.731e-07 3.3 2.76e-07 3.3 2.76e-07 0 2.79e-07 0 2.791e-07 0 2.82e-07 0 2.821e-07 0 2.85e-07 0 2.851e-07 0 2.88e-07 0 2.88e-07 0 2.91e-07 0 2.911e-07 0 2.94e-07 0 2.941e-07 0 2.97e-07 0 2.97e-07 0 3e-07 0 3e-07 3.3 3.03e-07 3.3 3.031e-07 3.3 3.06e-07 3.3 3.061e-07 3.3 3.09e-07 3.3 3.09e-07 3.3 3.12e-07 3.3 3.12e-07 3.3 3.15e-07 3.3 3.151e-07 3.3 3.18e-07 3.3 3.181e-07 3.3 3.21e-07 3.3 3.21e-07 3.3 3.24e-07 3.3 3.24e-07 0 3.27e-07 0 3.271e-07 0 3.3e-07 0 3.301e-07 0 3.33e-07 0 3.33e-07 0 3.36e-07 0 3.36e-07 0 3.39e-07 0 3.391e-07 0 3.42e-07 0 3.421e-07 0 3.45e-07 0 3.45e-07 0 3.48e-07 0 3.48e-07 3.3 3.51e-07 3.3 3.511e-07 3.3 3.54e-07 3.3 3.541e-07 3.3 3.57e-07 3.3 3.57e-07 3.3 3.6e-07 3.3 3.6e-07 3.3 3.63e-07 3.3 3.631e-07 3.3 3.66e-07 3.3 3.661e-07 3.3 3.69e-07 3.3 3.69e-07 3.3 3.72e-07 3.3 3.72e-07 0 3.75e-07 0 3.751e-07 0 3.78e-07 0 3.781e-07 0 3.81e-07 0 3.81e-07 0 3.84e-07 0 3.841e-07 0 3.87e-07 0 3.871e-07 0 3.9e-07 0 3.9e-07 0 3.93e-07 0 3.93e-07 0 3.96e-07 0 3.961e-07 3.3 3.99e-07 3.3 3.991e-07 3.3 4.02e-07 3.3 4.02e-07 3.3 4.05e-07 3.3 4.05e-07 3.3 4.08e-07 3.3 4.081e-07 3.3 4.11e-07 3.3 4.111e-07 3.3 4.14e-07 3.3 4.14e-07 3.3 4.17e-07 3.3 4.17e-07 3.3 4.2e-07 3.3 4.201e-07 0 4.23e-07 0 4.231e-07 0 4.26e-07 0 4.26e-07 0 4.29e-07 0 4.29e-07 0 4.32e-07 0 4.321e-07 0 4.35e-07 0 4.351e-07 0 4.38e-07 0 4.38e-07 0 4.41e-07 0 4.41e-07 0 4.44e-07 0 4.441e-07 3.3 4.47e-07 3.3 4.471e-07 3.3 4.5e-07 3.3 4.5e-07 3.3 4.53e-07 3.3 4.53e-07 3.3 4.56e-07 3.3 4.561e-07 3.3 4.59e-07 3.3 4.591e-07 3.3 4.62e-07 3.3 4.62e-07 3.3 4.65e-07 3.3 4.65e-07 3.3 4.68e-07 3.3 4.681e-07 0 4.71e-07 0 4.711e-07 0 4.74e-07 0 4.74e-07 0 4.77e-07 0 4.771e-07 0 4.8e-07 0 4.8e-07 0 4.83e-07 0 4.83e-07 0 4.86e-07 0 4.86e-07 0 4.89e-07 0 4.891e-07 0 4.92e-07 0 4.921e-07 3.3 4.95e-07 3.3 4.951e-07 3.3 4.98e-07 3.3 4.981e-07 3.3 5.01e-07 3.3 5.01e-07 3.3 5.04e-07 3.3 5.04e-07 3.3 5.07e-07 3.3 5.07e-07 3.3 5.1e-07 3.3 5.1e-07 3.3 5.13e-07 3.3 5.131e-07 3.3 5.16e-07 3.3 5.161e-07 0 5.19e-07 0 5.191e-07 0 5.22e-07 0 5.221e-07 0 5.25e-07 0 5.25e-07 0 5.28e-07 0 5.28e-07 0 5.31e-07 0 5.31e-07 0 5.34e-07 0 5.34e-07 0 5.37e-07 0 5.371e-07 0 5.4e-07 0 5.401e-07 3.3 5.43e-07 3.3 5.431e-07 3.3 5.46e-07 3.3 5.461e-07 3.3 5.49e-07 3.3 5.49e-07 3.3 5.52e-07 3.3 5.52e-07 3.3 5.55e-07 3.3 5.55e-07 3.3 5.58e-07 3.3 5.58e-07 3.3 5.61e-07 3.3 5.611e-07 3.3 5.64e-07 3.3 5.641e-07 0 5.67e-07 0 5.671e-07 0 5.7e-07 0 5.701e-07 0 5.73e-07 0 5.73e-07 0 5.76e-07 0 5.76e-07 0 5.79e-07 0 5.79e-07 0 5.82e-07 0 5.821e-07 0 5.85e-07 0 5.851e-07 0 5.88e-07 0 5.881e-07 3.3 5.91e-07 3.3 5.911e-07 3.3 5.94e-07 3.3 5.94e-07 3.3 5.97e-07 3.3 5.97e-07 3.3 6e-07 3.3 6e-07 3.3 6.03e-07 3.3 6.03e-07 3.3 6.06e-07 3.3 6.061e-07 3.3 6.09e-07 3.3 6.091e-07 3.3 6.12e-07 3.3 6.121e-07 0 6.15e-07 0 6.151e-07 0 6.18e-07 0 6.18e-07 0 6.21e-07 0 6.21e-07 0 6.24e-07 0 6.24e-07 0 6.27e-07 0 6.27e-07 0 6.3e-07 0 6.301e-07 0 6.33e-07 0 6.331e-07 0 6.36e-07 0 6.361e-07 3.3 6.39e-07 3.3 6.391e-07 3.3 6.42e-07 3.3 6.42e-07 3.3 6.45e-07 3.3 6.45e-07 3.3 6.48e-07 3.3 6.48e-07 3.3 6.51e-07 3.3 6.51e-07 3.3 6.54e-07 3.3 6.541e-07 3.3 6.57e-07 3.3 6.571e-07 3.3 6.6e-07 3.3 6.601e-07 0 6.63e-07 0 6.631e-07 0 6.66e-07 0 6.66e-07 0 6.69e-07 0 6.69e-07 0 6.72e-07 0 6.72e-07 0 6.75e-07 0 6.75e-07 0 6.78e-07 0 6.781e-07 0 6.81e-07 0 6.811e-07 0 6.84e-07 0 6.841e-07 3.3 6.87e-07 3.3 6.87e-07 3.3 6.9e-07 3.3 6.9e-07 3.3 6.93e-07 3.3 6.93e-07 3.3 6.96e-07 3.3 6.96e-07 3.3 6.99e-07 3.3 6.991e-07 3.3 7.02e-07 3.3 7.021e-07 3.3 7.05e-07 3.3 7.051e-07 3.3 7.08e-07 3.3 7.081e-07 0 7.11e-07 0 7.11e-07 0 7.14e-07 0 7.14e-07 0 7.17e-07 0 7.17e-07 0 7.2e-07 0 7.2e-07 0 7.23e-07 0 7.231e-07 0 7.26e-07 0 7.261e-07 0 7.29e-07 0 7.291e-07 0 7.32e-07 0 7.321e-07 3.3 7.35e-07 3.3 7.35e-07 3.3 7.38e-07 3.3 7.38e-07 3.3 7.41e-07 3.3 7.41e-07 3.3 7.44e-07 3.3 7.44e-07 3.3 7.47e-07 3.3 7.471e-07 3.3 7.5e-07 3.3 7.501e-07 3.3 7.53e-07 3.3 7.531e-07 3.3 7.56e-07 3.3 7.561e-07 0 7.59e-07 0 7.59e-07 0 7.62e-07 0 7.62e-07 0 7.65e-07 0 7.65e-07 0 7.68e-07 0 7.68e-07 0 7.71e-07 0 7.711e-07 0 7.74e-07 0 7.741e-07 0 7.77e-07 0 7.771e-07 0 7.8e-07 0 7.8e-07 3.3 7.83e-07 3.3 7.83e-07 3.3 7.86e-07 3.3 7.86e-07 3.3 7.89e-07 3.3 7.89e-07 3.3 7.92e-07 3.3 7.921e-07 3.3 7.95e-07 3.3 7.951e-07 3.3 7.98e-07 3.3 7.981e-07 3.3 8.01e-07 3.3 8.011e-07 3.3 8.04e-07 3.3 8.04e-07 0 8.07e-07 0 8.07e-07 0 8.1e-07 0 8.1e-07 0 8.13e-07 0 8.13e-07 0 8.16e-07 0 8.161e-07 0 8.19e-07 0 8.191e-07 0 8.22e-07 0 8.221e-07 0 8.25e-07 0 8.251e-07 0 8.28e-07 0 8.28e-07 3.3 8.31e-07 3.3 8.31e-07 3.3 8.34e-07 3.3 8.34e-07 3.3 8.37e-07 3.3 8.37e-07 3.3 8.4e-07 3.3 8.401e-07 3.3 8.43e-07 3.3 8.431e-07 3.3 8.46e-07 3.3 8.461e-07 3.3 8.49e-07 3.3 8.491e-07 3.3 8.52e-07 3.3 8.52e-07 0 8.55e-07 0 8.55e-07 0 8.58e-07 0 8.58e-07 0 8.61e-07 0 8.61e-07 0 8.64e-07 0 8.641e-07 0 8.67e-07 0 8.671e-07 0 8.7e-07 0 8.701e-07 0 8.73e-07 0 8.73e-07 0 8.76e-07 0 8.76e-07 3.3 8.79e-07 3.3 8.79e-07 3.3 8.82e-07 3.3 8.82e-07 3.3 8.85e-07 3.3 8.851e-07 3.3 8.88e-07 3.3 8.881e-07 3.3 8.91e-07 3.3 8.911e-07 3.3 8.94e-07 3.3 8.941e-07 3.3 8.97e-07 3.3 8.97e-07 3.3 9e-07 3.3 9e-07 0 9.03e-07 0 9.03e-07 0 9.06e-07 0 9.06e-07 0 9.09e-07 0 9.091e-07 0 9.12e-07 0 9.121e-07 0 9.15e-07 0 9.151e-07 0 9.18e-07 0 9.181e-07 0 9.21e-07 0 9.21e-07 0 9.24e-07 0 9.24e-07 3.3 9.27e-07 3.3 9.27e-07 3.3 9.3e-07 3.3 9.3e-07 3.3 9.33e-07 3.3 9.331e-07 3.3 9.36e-07 3.3 9.361e-07 3.3 9.39e-07 3.3 9.391e-07 3.3 9.42e-07 3.3 9.421e-07 3.3 9.45e-07 3.3 9.45e-07 3.3 9.48e-07 3.3 9.48e-07 0 9.51e-07 0 9.51e-07 0 9.54e-07 0 9.54e-07 0 9.57e-07 0 9.57e-07 0 9.6e-07 0 9.6e-07 0 9.63e-07 0 9.63e-07 0 9.66e-07 0 9.66e-07 0 9.69e-07 0 9.69e-07 0 9.72e-07 0 9.72e-07 3.3 9.75e-07 3.3 9.75e-07 3.3 9.78e-07 3.3 9.78e-07 3.3 9.81e-07 3.3 9.81e-07 3.3 9.84e-07 3.3 9.84e-07 3.3 9.87e-07 3.3 9.87e-07 3.3 9.9e-07 3.3 9.9e-07 3.3 9.93e-07 3.3 9.93e-07 3.3 9.96e-07 3.3 9.96e-07 0 9.99e-07 0 9.99e-07 0 1.002e-06 0 1.002e-06 0 1.005e-06 0 1.005e-06 0 1.008e-06 0 1.008e-06 0 1.011e-06 0 1.011e-06 0 1.014e-06 0 1.014e-06 0 1.017e-06 0 1.017e-06 0 1.02e-06 0 1.02e-06 3.3 1.023e-06 3.3 1.023e-06 3.3 1.026e-06 3.3 1.026e-06 3.3 1.029e-06 3.3 1.029e-06 3.3 1.032e-06 3.3 1.032e-06 3.3 1.035e-06 3.3 1.035e-06 3.3 1.038e-06 3.3 1.038e-06 3.3 1.041e-06 3.3 1.041e-06 3.3 1.044e-06 3.3 1.044e-06 0 1.047e-06 0 1.047e-06 0 1.05e-06 0 1.05e-06 0 1.053e-06 0 1.053e-06 0 1.056e-06 0 1.056e-06 0 1.059e-06 0 1.059e-06 0 1.062e-06 0 1.062e-06 0 1.065e-06 0 1.065e-06 0 1.068e-06 0 1.068e-06 3.3 1.071e-06 3.3 1.071e-06 3.3 1.074e-06 3.3 1.074e-06 3.3 1.077e-06 3.3 1.077e-06 3.3 1.08e-06 3.3 1.08e-06 3.3 1.083e-06 3.3 1.083e-06 3.3 1.086e-06 3.3 1.086e-06 3.3 1.089e-06 3.3 1.089e-06 3.3 1.092e-06 3.3 1.092e-06 0 1.095e-06 0 1.095e-06 0 1.098e-06 0 1.098e-06 0 1.101e-06 0 1.101e-06 0 1.104e-06 0 1.104e-06 0 1.107e-06 0 1.107e-06 0 1.11e-06 0 1.11e-06 0 1.113e-06 0 1.113e-06 0 1.116e-06 0 1.116e-06 3.3 1.119e-06 3.3 1.119e-06 3.3 1.122e-06 3.3 1.122e-06 3.3 1.125e-06 3.3 1.125e-06 3.3 1.128e-06 3.3 1.128e-06 3.3 1.131e-06 3.3 1.131e-06 3.3 1.134e-06 3.3 1.134e-06 3.3 1.137e-06 3.3 1.137e-06 3.3 1.14e-06 3.3 1.14e-06 0 1.143e-06 0 1.143e-06 0 1.146e-06 0 1.146e-06 0 1.149e-06 0 1.149e-06 0 1.152e-06 0 1.152e-06 0 1.155e-06 0 1.155e-06 0 1.158e-06 0 1.158e-06 0 1.161e-06 0 1.161e-06 0 1.164e-06 0 1.164e-06 3.3 1.167e-06 3.3 1.167e-06 3.3 1.17e-06 3.3 1.17e-06 3.3 1.173e-06 3.3 1.173e-06 3.3 1.176e-06 3.3 1.176e-06 3.3 1.179e-06 3.3 1.179e-06 3.3 1.182e-06 3.3 1.182e-06 3.3 1.185e-06 3.3 1.185e-06 3.3 1.188e-06 3.3 1.188e-06 0 1.191e-06 0 1.191e-06 0 1.194e-06 0 1.194e-06 0 1.197e-06 0 1.197e-06 0 1.2e-06 0 1.2e-06 0 1.203e-06 0 1.203e-06 0 1.206e-06 0 1.206e-06 0 1.209e-06 0 1.209e-06 0 1.212e-06 0 1.212e-06 3.3 1.215e-06 3.3 1.215e-06 3.3 1.218e-06 3.3 1.218e-06 3.3 1.221e-06 3.3 1.221e-06 3.3 1.224e-06 3.3 1.224e-06 3.3 1.227e-06 3.3 1.227e-06 3.3 1.23e-06 3.3 1.23e-06 3.3 1.233e-06 3.3 1.233e-06 3.3 1.236e-06 3.3 1.236e-06 0 1.239e-06 0 1.239e-06 0 1.242e-06 0 1.242e-06 0 1.245e-06 0 1.245e-06 0 1.248e-06 0 1.248e-06 0 1.251e-06 0 1.251e-06 0 1.254e-06 0 1.254e-06 0 1.257e-06 0 1.257e-06 0 1.26e-06 0 1.26e-06 3.3 1.263e-06 3.3 1.263e-06 3.3 1.266e-06 3.3 1.266e-06 3.3 1.269e-06 3.3 1.269e-06 3.3 1.272e-06 3.3 1.272e-06 3.3 1.275e-06 3.3 1.275e-06 3.3 1.278e-06 3.3 1.278e-06 3.3 1.281e-06 3.3 1.281e-06 3.3 1.284e-06 3.3 1.284e-06 0 1.287e-06 0 1.287e-06 0 1.29e-06 0 1.29e-06 0 1.293e-06 0 1.293e-06 0 1.296e-06 0 1.296e-06 0 1.299e-06 0 1.299e-06 0 1.302e-06 0 1.302e-06 0 1.305e-06 0 1.305e-06 0 1.308e-06 0 1.308e-06 3.3 1.311e-06 3.3 1.311e-06 3.3 1.314e-06 3.3 1.314e-06 3.3 1.317e-06 3.3 1.317e-06 3.3 1.32e-06 3.3 1.32e-06 3.3 1.323e-06 3.3 1.323e-06 3.3 1.326e-06 3.3 1.326e-06 3.3 1.329e-06 3.3 1.329e-06 3.3 1.332e-06 3.3 1.332e-06 0 1.335e-06 0 1.335e-06 0 1.338e-06 0 1.338e-06 0 1.341e-06 0 1.341e-06 0 1.344e-06 0 1.344e-06 0 1.347e-06 0 1.347e-06 0 1.35e-06 0 1.35e-06 0 1.353e-06 0 1.353e-06 0 1.356e-06 0 1.356e-06 3.3 1.359e-06 3.3 1.359e-06 3.3 1.362e-06 3.3 1.362e-06 3.3 1.365e-06 3.3 1.365e-06 3.3 1.368e-06 3.3 1.368e-06 3.3 1.371e-06 3.3 1.371e-06 3.3 1.374e-06 3.3 1.374e-06 3.3 1.377e-06 3.3 1.377e-06 3.3 1.38e-06 3.3 1.38e-06 0 1.383e-06 0 1.383e-06 0 1.386e-06 0 1.386e-06 0 1.389e-06 0 1.389e-06 0 1.392e-06 0 1.392e-06 0 1.395e-06 0 1.395e-06 0 1.398e-06 0 1.398e-06 0 1.401e-06 0 1.401e-06 0 1.404e-06 0 1.404e-06 3.3 1.407e-06 3.3 1.407e-06 3.3 1.41e-06 3.3 1.41e-06 3.3 1.413e-06 3.3 1.413e-06 3.3 1.416e-06 3.3 1.416e-06 3.3 1.419e-06 3.3 1.419e-06 3.3 1.422e-06 3.3 1.422e-06 3.3 1.425e-06 3.3 1.425e-06 3.3 1.428e-06 3.3 1.428e-06 0 1.431e-06 0 1.431e-06 0 1.434e-06 0 1.434e-06 0 1.437e-06 0 1.437e-06 0 1.44e-06 0 1.44e-06 0 1.443e-06 0 1.443e-06 0 1.446e-06 0 1.446e-06 0 1.449e-06 0 1.449e-06 0 1.452e-06 0 1.452e-06 3.3 1.455e-06 3.3 1.455e-06 3.3 1.458e-06 3.3 1.458e-06 3.3 1.461e-06 3.3 1.461e-06 3.3 1.464e-06 3.3 1.464e-06 3.3 1.467e-06 3.3 1.467e-06 3.3 1.47e-06 3.3 1.47e-06 3.3 1.473e-06 3.3 1.473e-06 3.3 1.476e-06 3.3 1.476e-06 0 1.479e-06 0 1.479e-06 0 1.482e-06 0 1.482e-06 0 1.485e-06 0 1.485e-06 0 1.488e-06 0 1.488e-06 0 1.491e-06 0 1.491e-06 0 1.494e-06 0 1.494e-06 0 1.497e-06 0 1.497e-06 0 1.5e-06 0 1.5e-06 3.3 1.503e-06 3.3 1.503e-06 3.3 1.506e-06 3.3 1.506e-06 3.3 1.509e-06 3.3 1.509e-06 3.3 1.512e-06 3.3 1.512e-06 3.3 1.515e-06 3.3 1.515e-06 3.3 1.518e-06 3.3 1.518e-06 3.3 1.521e-06 3.3 1.521e-06 3.3 1.524e-06 3.3 1.524e-06 0 1.527e-06 0 1.527e-06 0 1.53e-06 0 1.53e-06 0 1.533e-06 0 1.533e-06 0)
VA3 A3 0 PWL(0 0 3e-09 0 3.05e-09 0 6e-09 0 6.05e-09 0 9e-09 0 9.05e-09 0 1.2e-08 0 1.205e-08 0 1.5e-08 0 1.505e-08 0 1.8e-08 0 1.805e-08 0 2.1e-08 0 2.105e-08 0 2.4e-08 0 2.405e-08 3.3 2.7e-08 3.3 2.705e-08 3.3 3e-08 3.3 3.005e-08 3.3 3.3e-08 3.3 3.305e-08 3.3 3.6e-08 3.3 3.605e-08 3.3 3.9e-08 3.3 3.905e-08 3.3 4.2e-08 3.3 4.205e-08 3.3 4.5e-08 3.3 4.505e-08 3.3 4.8e-08 3.3 4.805e-08 3.3 5.1e-08 3.3 5.105e-08 3.3 5.4e-08 3.3 5.405e-08 3.3 5.7e-08 3.3 5.705e-08 3.3 6e-08 3.3 6.005e-08 3.3 6.3e-08 3.3 6.305e-08 3.3 6.6e-08 3.3 6.605e-08 3.3 6.9e-08 3.3 6.905e-08 3.3 7.2e-08 3.3 7.205e-08 0 7.5e-08 0 7.505e-08 0 7.8e-08 0 7.805e-08 0 8.1e-08 0 8.105e-08 0 8.4e-08 0 8.405e-08 0 8.7e-08 0 8.705e-08 0 9e-08 0 9.005e-08 0 9.3e-08 0 9.305e-08 0 9.6e-08 0 9.605e-08 0 9.9e-08 0 9.905e-08 0 1.02e-07 0 1.021e-07 0 1.05e-07 0 1.051e-07 0 1.08e-07 0 1.081e-07 0 1.11e-07 0 1.111e-07 0 1.14e-07 0 1.141e-07 0 1.17e-07 0 1.171e-07 0 1.2e-07 0 1.2e-07 3.3 1.23e-07 3.3 1.231e-07 3.3 1.26e-07 3.3 1.26e-07 3.3 1.29e-07 3.3 1.291e-07 3.3 1.32e-07 3.3 1.32e-07 3.3 1.35e-07 3.3 1.351e-07 3.3 1.38e-07 3.3 1.38e-07 3.3 1.41e-07 3.3 1.411e-07 3.3 1.44e-07 3.3 1.44e-07 3.3 1.47e-07 3.3 1.471e-07 3.3 1.5e-07 3.3 1.5e-07 3.3 1.53e-07 3.3 1.531e-07 3.3 1.56e-07 3.3 1.56e-07 3.3 1.59e-07 3.3 1.591e-07 3.3 1.62e-07 3.3 1.62e-07 3.3 1.65e-07 3.3 1.651e-07 3.3 1.68e-07 3.3 1.68e-07 0 1.71e-07 0 1.711e-07 0 1.74e-07 0 1.741e-07 0 1.77e-07 0 1.771e-07 0 1.8e-07 0 1.801e-07 0 1.83e-07 0 1.831e-07 0 1.86e-07 0 1.861e-07 0 1.89e-07 0 1.891e-07 0 1.92e-07 0 1.921e-07 0 1.95e-07 0 1.95e-07 0 1.98e-07 0 1.981e-07 0 2.01e-07 0 2.01e-07 0 2.04e-07 0 2.041e-07 0 2.07e-07 0 2.07e-07 0 2.1e-07 0 2.101e-07 0 2.13e-07 0 2.13e-07 0 2.16e-07 0 2.161e-07 3.3 2.19e-07 3.3 2.19e-07 3.3 2.22e-07 3.3 2.221e-07 3.3 2.25e-07 3.3 2.25e-07 3.3 2.28e-07 3.3 2.281e-07 3.3 2.31e-07 3.3 2.31e-07 3.3 2.34e-07 3.3 2.341e-07 3.3 2.37e-07 3.3 2.37e-07 3.3 2.4e-07 3.3 2.4e-07 3.3 2.43e-07 3.3 2.43e-07 3.3 2.46e-07 3.3 2.461e-07 3.3 2.49e-07 3.3 2.491e-07 3.3 2.52e-07 3.3 2.52e-07 3.3 2.55e-07 3.3 2.55e-07 3.3 2.58e-07 3.3 2.581e-07 3.3 2.61e-07 3.3 2.611e-07 3.3 2.64e-07 3.3 2.64e-07 0 2.67e-07 0 2.67e-07 0 2.7e-07 0 2.701e-07 0 2.73e-07 0 2.731e-07 0 2.76e-07 0 2.76e-07 0 2.79e-07 0 2.791e-07 0 2.82e-07 0 2.821e-07 0 2.85e-07 0 2.851e-07 0 2.88e-07 0 2.88e-07 0 2.91e-07 0 2.911e-07 0 2.94e-07 0 2.941e-07 0 2.97e-07 0 2.97e-07 0 3e-07 0 3e-07 0 3.03e-07 0 3.031e-07 0 3.06e-07 0 3.061e-07 0 3.09e-07 0 3.09e-07 0 3.12e-07 0 3.12e-07 3.3 3.15e-07 3.3 3.151e-07 3.3 3.18e-07 3.3 3.181e-07 3.3 3.21e-07 3.3 3.21e-07 3.3 3.24e-07 3.3 3.24e-07 3.3 3.27e-07 3.3 3.271e-07 3.3 3.3e-07 3.3 3.301e-07 3.3 3.33e-07 3.3 3.33e-07 3.3 3.36e-07 3.3 3.36e-07 3.3 3.39e-07 3.3 3.391e-07 3.3 3.42e-07 3.3 3.421e-07 3.3 3.45e-07 3.3 3.45e-07 3.3 3.48e-07 3.3 3.48e-07 3.3 3.51e-07 3.3 3.511e-07 3.3 3.54e-07 3.3 3.541e-07 3.3 3.57e-07 3.3 3.57e-07 3.3 3.6e-07 3.3 3.6e-07 0 3.63e-07 0 3.631e-07 0 3.66e-07 0 3.661e-07 0 3.69e-07 0 3.69e-07 0 3.72e-07 0 3.72e-07 0 3.75e-07 0 3.751e-07 0 3.78e-07 0 3.781e-07 0 3.81e-07 0 3.81e-07 0 3.84e-07 0 3.841e-07 0 3.87e-07 0 3.871e-07 0 3.9e-07 0 3.9e-07 0 3.93e-07 0 3.93e-07 0 3.96e-07 0 3.961e-07 0 3.99e-07 0 3.991e-07 0 4.02e-07 0 4.02e-07 0 4.05e-07 0 4.05e-07 0 4.08e-07 0 4.081e-07 3.3 4.11e-07 3.3 4.111e-07 3.3 4.14e-07 3.3 4.14e-07 3.3 4.17e-07 3.3 4.17e-07 3.3 4.2e-07 3.3 4.201e-07 3.3 4.23e-07 3.3 4.231e-07 3.3 4.26e-07 3.3 4.26e-07 3.3 4.29e-07 3.3 4.29e-07 3.3 4.32e-07 3.3 4.321e-07 3.3 4.35e-07 3.3 4.351e-07 3.3 4.38e-07 3.3 4.38e-07 3.3 4.41e-07 3.3 4.41e-07 3.3 4.44e-07 3.3 4.441e-07 3.3 4.47e-07 3.3 4.471e-07 3.3 4.5e-07 3.3 4.5e-07 3.3 4.53e-07 3.3 4.53e-07 3.3 4.56e-07 3.3 4.561e-07 0 4.59e-07 0 4.591e-07 0 4.62e-07 0 4.62e-07 0 4.65e-07 0 4.65e-07 0 4.68e-07 0 4.681e-07 0 4.71e-07 0 4.711e-07 0 4.74e-07 0 4.74e-07 0 4.77e-07 0 4.771e-07 0 4.8e-07 0 4.8e-07 0 4.83e-07 0 4.83e-07 0 4.86e-07 0 4.86e-07 0 4.89e-07 0 4.891e-07 0 4.92e-07 0 4.921e-07 0 4.95e-07 0 4.951e-07 0 4.98e-07 0 4.981e-07 0 5.01e-07 0 5.01e-07 0 5.04e-07 0 5.04e-07 3.3 5.07e-07 3.3 5.07e-07 3.3 5.1e-07 3.3 5.1e-07 3.3 5.13e-07 3.3 5.131e-07 3.3 5.16e-07 3.3 5.161e-07 3.3 5.19e-07 3.3 5.191e-07 3.3 5.22e-07 3.3 5.221e-07 3.3 5.25e-07 3.3 5.25e-07 3.3 5.28e-07 3.3 5.28e-07 3.3 5.31e-07 3.3 5.31e-07 3.3 5.34e-07 3.3 5.34e-07 3.3 5.37e-07 3.3 5.371e-07 3.3 5.4e-07 3.3 5.401e-07 3.3 5.43e-07 3.3 5.431e-07 3.3 5.46e-07 3.3 5.461e-07 3.3 5.49e-07 3.3 5.49e-07 3.3 5.52e-07 3.3 5.52e-07 0 5.55e-07 0 5.55e-07 0 5.58e-07 0 5.58e-07 0 5.61e-07 0 5.611e-07 0 5.64e-07 0 5.641e-07 0 5.67e-07 0 5.671e-07 0 5.7e-07 0 5.701e-07 0 5.73e-07 0 5.73e-07 0 5.76e-07 0 5.76e-07 0 5.79e-07 0 5.79e-07 0 5.82e-07 0 5.821e-07 0 5.85e-07 0 5.851e-07 0 5.88e-07 0 5.881e-07 0 5.91e-07 0 5.911e-07 0 5.94e-07 0 5.94e-07 0 5.97e-07 0 5.97e-07 0 6e-07 0 6e-07 3.3 6.03e-07 3.3 6.03e-07 3.3 6.06e-07 3.3 6.061e-07 3.3 6.09e-07 3.3 6.091e-07 3.3 6.12e-07 3.3 6.121e-07 3.3 6.15e-07 3.3 6.151e-07 3.3 6.18e-07 3.3 6.18e-07 3.3 6.21e-07 3.3 6.21e-07 3.3 6.24e-07 3.3 6.24e-07 3.3 6.27e-07 3.3 6.27e-07 3.3 6.3e-07 3.3 6.301e-07 3.3 6.33e-07 3.3 6.331e-07 3.3 6.36e-07 3.3 6.361e-07 3.3 6.39e-07 3.3 6.391e-07 3.3 6.42e-07 3.3 6.42e-07 3.3 6.45e-07 3.3 6.45e-07 3.3 6.48e-07 3.3 6.48e-07 0 6.51e-07 0 6.51e-07 0 6.54e-07 0 6.541e-07 0 6.57e-07 0 6.571e-07 0 6.6e-07 0 6.601e-07 0 6.63e-07 0 6.631e-07 0 6.66e-07 0 6.66e-07 0 6.69e-07 0 6.69e-07 0 6.72e-07 0 6.72e-07 0 6.75e-07 0 6.75e-07 0 6.78e-07 0 6.781e-07 0 6.81e-07 0 6.811e-07 0 6.84e-07 0 6.841e-07 0 6.87e-07 0 6.87e-07 0 6.9e-07 0 6.9e-07 0 6.93e-07 0 6.93e-07 0 6.96e-07 0 6.96e-07 3.3 6.99e-07 3.3 6.991e-07 3.3 7.02e-07 3.3 7.021e-07 3.3 7.05e-07 3.3 7.051e-07 3.3 7.08e-07 3.3 7.081e-07 3.3 7.11e-07 3.3 7.11e-07 3.3 7.14e-07 3.3 7.14e-07 3.3 7.17e-07 3.3 7.17e-07 3.3 7.2e-07 3.3 7.2e-07 3.3 7.23e-07 3.3 7.231e-07 3.3 7.26e-07 3.3 7.261e-07 3.3 7.29e-07 3.3 7.291e-07 3.3 7.32e-07 3.3 7.321e-07 3.3 7.35e-07 3.3 7.35e-07 3.3 7.38e-07 3.3 7.38e-07 3.3 7.41e-07 3.3 7.41e-07 3.3 7.44e-07 3.3 7.44e-07 0 7.47e-07 0 7.471e-07 0 7.5e-07 0 7.501e-07 0 7.53e-07 0 7.531e-07 0 7.56e-07 0 7.561e-07 0 7.59e-07 0 7.59e-07 0 7.62e-07 0 7.62e-07 0 7.65e-07 0 7.65e-07 0 7.68e-07 0 7.68e-07 0 7.71e-07 0 7.711e-07 0 7.74e-07 0 7.741e-07 0 7.77e-07 0 7.771e-07 0 7.8e-07 0 7.8e-07 0 7.83e-07 0 7.83e-07 0 7.86e-07 0 7.86e-07 0 7.89e-07 0 7.89e-07 0 7.92e-07 0 7.921e-07 3.3 7.95e-07 3.3 7.951e-07 3.3 7.98e-07 3.3 7.981e-07 3.3 8.01e-07 3.3 8.011e-07 3.3 8.04e-07 3.3 8.04e-07 3.3 8.07e-07 3.3 8.07e-07 3.3 8.1e-07 3.3 8.1e-07 3.3 8.13e-07 3.3 8.13e-07 3.3 8.16e-07 3.3 8.161e-07 3.3 8.19e-07 3.3 8.191e-07 3.3 8.22e-07 3.3 8.221e-07 3.3 8.25e-07 3.3 8.251e-07 3.3 8.28e-07 3.3 8.28e-07 3.3 8.31e-07 3.3 8.31e-07 3.3 8.34e-07 3.3 8.34e-07 3.3 8.37e-07 3.3 8.37e-07 3.3 8.4e-07 3.3 8.401e-07 0 8.43e-07 0 8.431e-07 0 8.46e-07 0 8.461e-07 0 8.49e-07 0 8.491e-07 0 8.52e-07 0 8.52e-07 0 8.55e-07 0 8.55e-07 0 8.58e-07 0 8.58e-07 0 8.61e-07 0 8.61e-07 0 8.64e-07 0 8.641e-07 0 8.67e-07 0 8.671e-07 0 8.7e-07 0 8.701e-07 0 8.73e-07 0 8.73e-07 0 8.76e-07 0 8.76e-07 0 8.79e-07 0 8.79e-07 0 8.82e-07 0 8.82e-07 0 8.85e-07 0 8.851e-07 0 8.88e-07 0 8.881e-07 3.3 8.91e-07 3.3 8.911e-07 3.3 8.94e-07 3.3 8.941e-07 3.3 8.97e-07 3.3 8.97e-07 3.3 9e-07 3.3 9e-07 3.3 9.03e-07 3.3 9.03e-07 3.3 9.06e-07 3.3 9.06e-07 3.3 9.09e-07 3.3 9.091e-07 3.3 9.12e-07 3.3 9.121e-07 3.3 9.15e-07 3.3 9.151e-07 3.3 9.18e-07 3.3 9.181e-07 3.3 9.21e-07 3.3 9.21e-07 3.3 9.24e-07 3.3 9.24e-07 3.3 9.27e-07 3.3 9.27e-07 3.3 9.3e-07 3.3 9.3e-07 3.3 9.33e-07 3.3 9.331e-07 3.3 9.36e-07 3.3 9.361e-07 0 9.39e-07 0 9.391e-07 0 9.42e-07 0 9.421e-07 0 9.45e-07 0 9.45e-07 0 9.48e-07 0 9.48e-07 0 9.51e-07 0 9.51e-07 0 9.54e-07 0 9.54e-07 0 9.57e-07 0 9.57e-07 0 9.6e-07 0 9.6e-07 0 9.63e-07 0 9.63e-07 0 9.66e-07 0 9.66e-07 0 9.69e-07 0 9.69e-07 0 9.72e-07 0 9.72e-07 0 9.75e-07 0 9.75e-07 0 9.78e-07 0 9.78e-07 0 9.81e-07 0 9.81e-07 0 9.84e-07 0 9.84e-07 3.3 9.87e-07 3.3 9.87e-07 3.3 9.9e-07 3.3 9.9e-07 3.3 9.93e-07 3.3 9.93e-07 3.3 9.96e-07 3.3 9.96e-07 3.3 9.99e-07 3.3 9.99e-07 3.3 1.002e-06 3.3 1.002e-06 3.3 1.005e-06 3.3 1.005e-06 3.3 1.008e-06 3.3 1.008e-06 3.3 1.011e-06 3.3 1.011e-06 3.3 1.014e-06 3.3 1.014e-06 3.3 1.017e-06 3.3 1.017e-06 3.3 1.02e-06 3.3 1.02e-06 3.3 1.023e-06 3.3 1.023e-06 3.3 1.026e-06 3.3 1.026e-06 3.3 1.029e-06 3.3 1.029e-06 3.3 1.032e-06 3.3 1.032e-06 0 1.035e-06 0 1.035e-06 0 1.038e-06 0 1.038e-06 0 1.041e-06 0 1.041e-06 0 1.044e-06 0 1.044e-06 0 1.047e-06 0 1.047e-06 0 1.05e-06 0 1.05e-06 0 1.053e-06 0 1.053e-06 0 1.056e-06 0 1.056e-06 0 1.059e-06 0 1.059e-06 0 1.062e-06 0 1.062e-06 0 1.065e-06 0 1.065e-06 0 1.068e-06 0 1.068e-06 0 1.071e-06 0 1.071e-06 0 1.074e-06 0 1.074e-06 0 1.077e-06 0 1.077e-06 0 1.08e-06 0 1.08e-06 3.3 1.083e-06 3.3 1.083e-06 3.3 1.086e-06 3.3 1.086e-06 3.3 1.089e-06 3.3 1.089e-06 3.3 1.092e-06 3.3 1.092e-06 3.3 1.095e-06 3.3 1.095e-06 3.3 1.098e-06 3.3 1.098e-06 3.3 1.101e-06 3.3 1.101e-06 3.3 1.104e-06 3.3 1.104e-06 3.3 1.107e-06 3.3 1.107e-06 3.3 1.11e-06 3.3 1.11e-06 3.3 1.113e-06 3.3 1.113e-06 3.3 1.116e-06 3.3 1.116e-06 3.3 1.119e-06 3.3 1.119e-06 3.3 1.122e-06 3.3 1.122e-06 3.3 1.125e-06 3.3 1.125e-06 3.3 1.128e-06 3.3 1.128e-06 0 1.131e-06 0 1.131e-06 0 1.134e-06 0 1.134e-06 0 1.137e-06 0 1.137e-06 0 1.14e-06 0 1.14e-06 0 1.143e-06 0 1.143e-06 0 1.146e-06 0 1.146e-06 0 1.149e-06 0 1.149e-06 0 1.152e-06 0 1.152e-06 0 1.155e-06 0 1.155e-06 0 1.158e-06 0 1.158e-06 0 1.161e-06 0 1.161e-06 0 1.164e-06 0 1.164e-06 0 1.167e-06 0 1.167e-06 0 1.17e-06 0 1.17e-06 0 1.173e-06 0 1.173e-06 0 1.176e-06 0 1.176e-06 3.3 1.179e-06 3.3 1.179e-06 3.3 1.182e-06 3.3 1.182e-06 3.3 1.185e-06 3.3 1.185e-06 3.3 1.188e-06 3.3 1.188e-06 3.3 1.191e-06 3.3 1.191e-06 3.3 1.194e-06 3.3 1.194e-06 3.3 1.197e-06 3.3 1.197e-06 3.3 1.2e-06 3.3 1.2e-06 3.3 1.203e-06 3.3 1.203e-06 3.3 1.206e-06 3.3 1.206e-06 3.3 1.209e-06 3.3 1.209e-06 3.3 1.212e-06 3.3 1.212e-06 3.3 1.215e-06 3.3 1.215e-06 3.3 1.218e-06 3.3 1.218e-06 3.3 1.221e-06 3.3 1.221e-06 3.3 1.224e-06 3.3 1.224e-06 0 1.227e-06 0 1.227e-06 0 1.23e-06 0 1.23e-06 0 1.233e-06 0 1.233e-06 0 1.236e-06 0 1.236e-06 0 1.239e-06 0 1.239e-06 0 1.242e-06 0 1.242e-06 0 1.245e-06 0 1.245e-06 0 1.248e-06 0 1.248e-06 0 1.251e-06 0 1.251e-06 0 1.254e-06 0 1.254e-06 0 1.257e-06 0 1.257e-06 0 1.26e-06 0 1.26e-06 0 1.263e-06 0 1.263e-06 0 1.266e-06 0 1.266e-06 0 1.269e-06 0 1.269e-06 0 1.272e-06 0 1.272e-06 3.3 1.275e-06 3.3 1.275e-06 3.3 1.278e-06 3.3 1.278e-06 3.3 1.281e-06 3.3 1.281e-06 3.3 1.284e-06 3.3 1.284e-06 3.3 1.287e-06 3.3 1.287e-06 3.3 1.29e-06 3.3 1.29e-06 3.3 1.293e-06 3.3 1.293e-06 3.3 1.296e-06 3.3 1.296e-06 3.3 1.299e-06 3.3 1.299e-06 3.3 1.302e-06 3.3 1.302e-06 3.3 1.305e-06 3.3 1.305e-06 3.3 1.308e-06 3.3 1.308e-06 3.3 1.311e-06 3.3 1.311e-06 3.3 1.314e-06 3.3 1.314e-06 3.3 1.317e-06 3.3 1.317e-06 3.3 1.32e-06 3.3 1.32e-06 0 1.323e-06 0 1.323e-06 0 1.326e-06 0 1.326e-06 0 1.329e-06 0 1.329e-06 0 1.332e-06 0 1.332e-06 0 1.335e-06 0 1.335e-06 0 1.338e-06 0 1.338e-06 0 1.341e-06 0 1.341e-06 0 1.344e-06 0 1.344e-06 0 1.347e-06 0 1.347e-06 0 1.35e-06 0 1.35e-06 0 1.353e-06 0 1.353e-06 0 1.356e-06 0 1.356e-06 0 1.359e-06 0 1.359e-06 0 1.362e-06 0 1.362e-06 0 1.365e-06 0 1.365e-06 0 1.368e-06 0 1.368e-06 3.3 1.371e-06 3.3 1.371e-06 3.3 1.374e-06 3.3 1.374e-06 3.3 1.377e-06 3.3 1.377e-06 3.3 1.38e-06 3.3 1.38e-06 3.3 1.383e-06 3.3 1.383e-06 3.3 1.386e-06 3.3 1.386e-06 3.3 1.389e-06 3.3 1.389e-06 3.3 1.392e-06 3.3 1.392e-06 3.3 1.395e-06 3.3 1.395e-06 3.3 1.398e-06 3.3 1.398e-06 3.3 1.401e-06 3.3 1.401e-06 3.3 1.404e-06 3.3 1.404e-06 3.3 1.407e-06 3.3 1.407e-06 3.3 1.41e-06 3.3 1.41e-06 3.3 1.413e-06 3.3 1.413e-06 3.3 1.416e-06 3.3 1.416e-06 0 1.419e-06 0 1.419e-06 0 1.422e-06 0 1.422e-06 0 1.425e-06 0 1.425e-06 0 1.428e-06 0 1.428e-06 0 1.431e-06 0 1.431e-06 0 1.434e-06 0 1.434e-06 0 1.437e-06 0 1.437e-06 0 1.44e-06 0 1.44e-06 0 1.443e-06 0 1.443e-06 0 1.446e-06 0 1.446e-06 0 1.449e-06 0 1.449e-06 0 1.452e-06 0 1.452e-06 0 1.455e-06 0 1.455e-06 0 1.458e-06 0 1.458e-06 0 1.461e-06 0 1.461e-06 0 1.464e-06 0 1.464e-06 3.3 1.467e-06 3.3 1.467e-06 3.3 1.47e-06 3.3 1.47e-06 3.3 1.473e-06 3.3 1.473e-06 3.3 1.476e-06 3.3 1.476e-06 3.3 1.479e-06 3.3 1.479e-06 3.3 1.482e-06 3.3 1.482e-06 3.3 1.485e-06 3.3 1.485e-06 3.3 1.488e-06 3.3 1.488e-06 3.3 1.491e-06 3.3 1.491e-06 3.3 1.494e-06 3.3 1.494e-06 3.3 1.497e-06 3.3 1.497e-06 3.3 1.5e-06 3.3 1.5e-06 3.3 1.503e-06 3.3 1.503e-06 3.3 1.506e-06 3.3 1.506e-06 3.3 1.509e-06 3.3 1.509e-06 3.3 1.512e-06 3.3 1.512e-06 0 1.515e-06 0 1.515e-06 0 1.518e-06 0 1.518e-06 0 1.521e-06 0 1.521e-06 0 1.524e-06 0 1.524e-06 0 1.527e-06 0 1.527e-06 0 1.53e-06 0 1.53e-06 0 1.533e-06 0 1.533e-06 0)
VB0 B0 0 PWL(0 0 3e-09 0 3.05e-09 0 6e-09 0 6.05e-09 0 9e-09 0 9.05e-09 0 1.2e-08 0 1.205e-08 0 1.5e-08 0 1.505e-08 0 1.8e-08 0 1.805e-08 0 2.1e-08 0 2.105e-08 0 2.4e-08 0 2.405e-08 0 2.7e-08 0 2.705e-08 0 3e-08 0 3.005e-08 0 3.3e-08 0 3.305e-08 0 3.6e-08 0 3.605e-08 0 3.9e-08 0 3.905e-08 0 4.2e-08 0 4.205e-08 0 4.5e-08 0 4.505e-08 0 4.8e-08 0 4.805e-08 3.3 5.1e-08 3.3 5.105e-08 3.3 5.4e-08 3.3 5.405e-08 3.3 5.7e-08 3.3 5.705e-08 3.3 6e-08 3.3 6.005e-08 3.3 6.3e-08 3.3 6.305e-08 3.3 6.6e-08 3.3 6.605e-08 3.3 6.9e-08 3.3 6.905e-08 3.3 7.2e-08 3.3 7.205e-08 3.3 7.5e-08 3.3 7.505e-08 3.3 7.8e-08 3.3 7.805e-08 3.3 8.1e-08 3.3 8.105e-08 3.3 8.4e-08 3.3 8.405e-08 3.3 8.7e-08 3.3 8.705e-08 3.3 9e-08 3.3 9.005e-08 3.3 9.3e-08 3.3 9.305e-08 3.3 9.6e-08 3.3 9.605e-08 3.3 9.9e-08 3.3 9.905e-08 3.3 1.02e-07 3.3 1.021e-07 3.3 1.05e-07 3.3 1.051e-07 3.3 1.08e-07 3.3 1.081e-07 3.3 1.11e-07 3.3 1.111e-07 3.3 1.14e-07 3.3 1.141e-07 3.3 1.17e-07 3.3 1.171e-07 3.3 1.2e-07 3.3 1.2e-07 3.3 1.23e-07 3.3 1.231e-07 3.3 1.26e-07 3.3 1.26e-07 3.3 1.29e-07 3.3 1.291e-07 3.3 1.32e-07 3.3 1.32e-07 3.3 1.35e-07 3.3 1.351e-07 3.3 1.38e-07 3.3 1.38e-07 3.3 1.41e-07 3.3 1.411e-07 3.3 1.44e-07 3.3 1.44e-07 0 1.47e-07 0 1.471e-07 0 1.5e-07 0 1.5e-07 0 1.53e-07 0 1.531e-07 0 1.56e-07 0 1.56e-07 0 1.59e-07 0 1.591e-07 0 1.62e-07 0 1.62e-07 0 1.65e-07 0 1.651e-07 0 1.68e-07 0 1.68e-07 0 1.71e-07 0 1.711e-07 0 1.74e-07 0 1.741e-07 0 1.77e-07 0 1.771e-07 0 1.8e-07 0 1.801e-07 0 1.83e-07 0 1.831e-07 0 1.86e-07 0 1.861e-07 0 1.89e-07 0 1.891e-07 0 1.92e-07 0 1.921e-07 0 1.95e-07 0 1.95e-07 0 1.98e-07 0 1.981e-07 0 2.01e-07 0 2.01e-07 0 2.04e-07 0 2.041e-07 0 2.07e-07 0 2.07e-07 0 2.1e-07 0 2.101e-07 0 2.13e-07 0 2.13e-07 0 2.16e-07 0 2.161e-07 0 2.19e-07 0 2.19e-07 0 2.22e-07 0 2.221e-07 0 2.25e-07 0 2.25e-07 0 2.28e-07 0 2.281e-07 0 2.31e-07 0 2.31e-07 0 2.34e-07 0 2.341e-07 0 2.37e-07 0 2.37e-07 0 2.4e-07 0 2.4e-07 3.3 2.43e-07 3.3 2.43e-07 3.3 2.46e-07 3.3 2.461e-07 3.3 2.49e-07 3.3 2.491e-07 3.3 2.52e-07 3.3 2.52e-07 3.3 2.55e-07 3.3 2.55e-07 3.3 2.58e-07 3.3 2.581e-07 3.3 2.61e-07 3.3 2.611e-07 3.3 2.64e-07 3.3 2.64e-07 3.3 2.67e-07 3.3 2.67e-07 3.3 2.7e-07 3.3 2.701e-07 3.3 2.73e-07 3.3 2.731e-07 3.3 2.76e-07 3.3 2.76e-07 3.3 2.79e-07 3.3 2.791e-07 3.3 2.82e-07 3.3 2.821e-07 3.3 2.85e-07 3.3 2.851e-07 3.3 2.88e-07 3.3 2.88e-07 3.3 2.91e-07 3.3 2.911e-07 3.3 2.94e-07 3.3 2.941e-07 3.3 2.97e-07 3.3 2.97e-07 3.3 3e-07 3.3 3e-07 3.3 3.03e-07 3.3 3.031e-07 3.3 3.06e-07 3.3 3.061e-07 3.3 3.09e-07 3.3 3.09e-07 3.3 3.12e-07 3.3 3.12e-07 3.3 3.15e-07 3.3 3.151e-07 3.3 3.18e-07 3.3 3.181e-07 3.3 3.21e-07 3.3 3.21e-07 3.3 3.24e-07 3.3 3.24e-07 3.3 3.27e-07 3.3 3.271e-07 3.3 3.3e-07 3.3 3.301e-07 3.3 3.33e-07 3.3 3.33e-07 3.3 3.36e-07 3.3 3.36e-07 0 3.39e-07 0 3.391e-07 0 3.42e-07 0 3.421e-07 0 3.45e-07 0 3.45e-07 0 3.48e-07 0 3.48e-07 0 3.51e-07 0 3.511e-07 0 3.54e-07 0 3.541e-07 0 3.57e-07 0 3.57e-07 0 3.6e-07 0 3.6e-07 0 3.63e-07 0 3.631e-07 0 3.66e-07 0 3.661e-07 0 3.69e-07 0 3.69e-07 0 3.72e-07 0 3.72e-07 0 3.75e-07 0 3.751e-07 0 3.78e-07 0 3.781e-07 0 3.81e-07 0 3.81e-07 0 3.84e-07 0 3.841e-07 0 3.87e-07 0 3.871e-07 0 3.9e-07 0 3.9e-07 0 3.93e-07 0 3.93e-07 0 3.96e-07 0 3.961e-07 0 3.99e-07 0 3.991e-07 0 4.02e-07 0 4.02e-07 0 4.05e-07 0 4.05e-07 0 4.08e-07 0 4.081e-07 0 4.11e-07 0 4.111e-07 0 4.14e-07 0 4.14e-07 0 4.17e-07 0 4.17e-07 0 4.2e-07 0 4.201e-07 0 4.23e-07 0 4.231e-07 0 4.26e-07 0 4.26e-07 0 4.29e-07 0 4.29e-07 0 4.32e-07 0 4.321e-07 3.3 4.35e-07 3.3 4.351e-07 3.3 4.38e-07 3.3 4.38e-07 3.3 4.41e-07 3.3 4.41e-07 3.3 4.44e-07 3.3 4.441e-07 3.3 4.47e-07 3.3 4.471e-07 3.3 4.5e-07 3.3 4.5e-07 3.3 4.53e-07 3.3 4.53e-07 3.3 4.56e-07 3.3 4.561e-07 3.3 4.59e-07 3.3 4.591e-07 3.3 4.62e-07 3.3 4.62e-07 3.3 4.65e-07 3.3 4.65e-07 3.3 4.68e-07 3.3 4.681e-07 3.3 4.71e-07 3.3 4.711e-07 3.3 4.74e-07 3.3 4.74e-07 3.3 4.77e-07 3.3 4.771e-07 3.3 4.8e-07 3.3 4.8e-07 3.3 4.83e-07 3.3 4.83e-07 3.3 4.86e-07 3.3 4.86e-07 3.3 4.89e-07 3.3 4.891e-07 3.3 4.92e-07 3.3 4.921e-07 3.3 4.95e-07 3.3 4.951e-07 3.3 4.98e-07 3.3 4.981e-07 3.3 5.01e-07 3.3 5.01e-07 3.3 5.04e-07 3.3 5.04e-07 3.3 5.07e-07 3.3 5.07e-07 3.3 5.1e-07 3.3 5.1e-07 3.3 5.13e-07 3.3 5.131e-07 3.3 5.16e-07 3.3 5.161e-07 3.3 5.19e-07 3.3 5.191e-07 3.3 5.22e-07 3.3 5.221e-07 3.3 5.25e-07 3.3 5.25e-07 3.3 5.28e-07 3.3 5.28e-07 0 5.31e-07 0 5.31e-07 0 5.34e-07 0 5.34e-07 0 5.37e-07 0 5.371e-07 0 5.4e-07 0 5.401e-07 0 5.43e-07 0 5.431e-07 0 5.46e-07 0 5.461e-07 0 5.49e-07 0 5.49e-07 0 5.52e-07 0 5.52e-07 0 5.55e-07 0 5.55e-07 0 5.58e-07 0 5.58e-07 0 5.61e-07 0 5.611e-07 0 5.64e-07 0 5.641e-07 0 5.67e-07 0 5.671e-07 0 5.7e-07 0 5.701e-07 0 5.73e-07 0 5.73e-07 0 5.76e-07 0 5.76e-07 0 5.79e-07 0 5.79e-07 0 5.82e-07 0 5.821e-07 0 5.85e-07 0 5.851e-07 0 5.88e-07 0 5.881e-07 0 5.91e-07 0 5.911e-07 0 5.94e-07 0 5.94e-07 0 5.97e-07 0 5.97e-07 0 6e-07 0 6e-07 0 6.03e-07 0 6.03e-07 0 6.06e-07 0 6.061e-07 0 6.09e-07 0 6.091e-07 0 6.12e-07 0 6.121e-07 0 6.15e-07 0 6.151e-07 0 6.18e-07 0 6.18e-07 0 6.21e-07 0 6.21e-07 0 6.24e-07 0 6.24e-07 3.3 6.27e-07 3.3 6.27e-07 3.3 6.3e-07 3.3 6.301e-07 3.3 6.33e-07 3.3 6.331e-07 3.3 6.36e-07 3.3 6.361e-07 3.3 6.39e-07 3.3 6.391e-07 3.3 6.42e-07 3.3 6.42e-07 3.3 6.45e-07 3.3 6.45e-07 3.3 6.48e-07 3.3 6.48e-07 3.3 6.51e-07 3.3 6.51e-07 3.3 6.54e-07 3.3 6.541e-07 3.3 6.57e-07 3.3 6.571e-07 3.3 6.6e-07 3.3 6.601e-07 3.3 6.63e-07 3.3 6.631e-07 3.3 6.66e-07 3.3 6.66e-07 3.3 6.69e-07 3.3 6.69e-07 3.3 6.72e-07 3.3 6.72e-07 3.3 6.75e-07 3.3 6.75e-07 3.3 6.78e-07 3.3 6.781e-07 3.3 6.81e-07 3.3 6.811e-07 3.3 6.84e-07 3.3 6.841e-07 3.3 6.87e-07 3.3 6.87e-07 3.3 6.9e-07 3.3 6.9e-07 3.3 6.93e-07 3.3 6.93e-07 3.3 6.96e-07 3.3 6.96e-07 3.3 6.99e-07 3.3 6.991e-07 3.3 7.02e-07 3.3 7.021e-07 3.3 7.05e-07 3.3 7.051e-07 3.3 7.08e-07 3.3 7.081e-07 3.3 7.11e-07 3.3 7.11e-07 3.3 7.14e-07 3.3 7.14e-07 3.3 7.17e-07 3.3 7.17e-07 3.3 7.2e-07 3.3 7.2e-07 0 7.23e-07 0 7.231e-07 0 7.26e-07 0 7.261e-07 0 7.29e-07 0 7.291e-07 0 7.32e-07 0 7.321e-07 0 7.35e-07 0 7.35e-07 0 7.38e-07 0 7.38e-07 0 7.41e-07 0 7.41e-07 0 7.44e-07 0 7.44e-07 0 7.47e-07 0 7.471e-07 0 7.5e-07 0 7.501e-07 0 7.53e-07 0 7.531e-07 0 7.56e-07 0 7.561e-07 0 7.59e-07 0 7.59e-07 0 7.62e-07 0 7.62e-07 0 7.65e-07 0 7.65e-07 0 7.68e-07 0 7.68e-07 0 7.71e-07 0 7.711e-07 0 7.74e-07 0 7.741e-07 0 7.77e-07 0 7.771e-07 0 7.8e-07 0 7.8e-07 0 7.83e-07 0 7.83e-07 0 7.86e-07 0 7.86e-07 0 7.89e-07 0 7.89e-07 0 7.92e-07 0 7.921e-07 0 7.95e-07 0 7.951e-07 0 7.98e-07 0 7.981e-07 0 8.01e-07 0 8.011e-07 0 8.04e-07 0 8.04e-07 0 8.07e-07 0 8.07e-07 0 8.1e-07 0 8.1e-07 0 8.13e-07 0 8.13e-07 0 8.16e-07 0 8.161e-07 3.3 8.19e-07 3.3 8.191e-07 3.3 8.22e-07 3.3 8.221e-07 3.3 8.25e-07 3.3 8.251e-07 3.3 8.28e-07 3.3 8.28e-07 3.3 8.31e-07 3.3 8.31e-07 3.3 8.34e-07 3.3 8.34e-07 3.3 8.37e-07 3.3 8.37e-07 3.3 8.4e-07 3.3 8.401e-07 3.3 8.43e-07 3.3 8.431e-07 3.3 8.46e-07 3.3 8.461e-07 3.3 8.49e-07 3.3 8.491e-07 3.3 8.52e-07 3.3 8.52e-07 3.3 8.55e-07 3.3 8.55e-07 3.3 8.58e-07 3.3 8.58e-07 3.3 8.61e-07 3.3 8.61e-07 3.3 8.64e-07 3.3 8.641e-07 3.3 8.67e-07 3.3 8.671e-07 3.3 8.7e-07 3.3 8.701e-07 3.3 8.73e-07 3.3 8.73e-07 3.3 8.76e-07 3.3 8.76e-07 3.3 8.79e-07 3.3 8.79e-07 3.3 8.82e-07 3.3 8.82e-07 3.3 8.85e-07 3.3 8.851e-07 3.3 8.88e-07 3.3 8.881e-07 3.3 8.91e-07 3.3 8.911e-07 3.3 8.94e-07 3.3 8.941e-07 3.3 8.97e-07 3.3 8.97e-07 3.3 9e-07 3.3 9e-07 3.3 9.03e-07 3.3 9.03e-07 3.3 9.06e-07 3.3 9.06e-07 3.3 9.09e-07 3.3 9.091e-07 3.3 9.12e-07 3.3 9.121e-07 0 9.15e-07 0 9.151e-07 0 9.18e-07 0 9.181e-07 0 9.21e-07 0 9.21e-07 0 9.24e-07 0 9.24e-07 0 9.27e-07 0 9.27e-07 0 9.3e-07 0 9.3e-07 0 9.33e-07 0 9.331e-07 0 9.36e-07 0 9.361e-07 0 9.39e-07 0 9.391e-07 0 9.42e-07 0 9.421e-07 0 9.45e-07 0 9.45e-07 0 9.48e-07 0 9.48e-07 0 9.51e-07 0 9.51e-07 0 9.54e-07 0 9.54e-07 0 9.57e-07 0 9.57e-07 0 9.6e-07 0 9.6e-07 0 9.63e-07 0 9.63e-07 0 9.66e-07 0 9.66e-07 0 9.69e-07 0 9.69e-07 0 9.72e-07 0 9.72e-07 0 9.75e-07 0 9.75e-07 0 9.78e-07 0 9.78e-07 0 9.81e-07 0 9.81e-07 0 9.84e-07 0 9.84e-07 0 9.87e-07 0 9.87e-07 0 9.9e-07 0 9.9e-07 0 9.93e-07 0 9.93e-07 0 9.96e-07 0 9.96e-07 0 9.99e-07 0 9.99e-07 0 1.002e-06 0 1.002e-06 0 1.005e-06 0 1.005e-06 0 1.008e-06 0 1.008e-06 3.3 1.011e-06 3.3 1.011e-06 3.3 1.014e-06 3.3 1.014e-06 3.3 1.017e-06 3.3 1.017e-06 3.3 1.02e-06 3.3 1.02e-06 3.3 1.023e-06 3.3 1.023e-06 3.3 1.026e-06 3.3 1.026e-06 3.3 1.029e-06 3.3 1.029e-06 3.3 1.032e-06 3.3 1.032e-06 3.3 1.035e-06 3.3 1.035e-06 3.3 1.038e-06 3.3 1.038e-06 3.3 1.041e-06 3.3 1.041e-06 3.3 1.044e-06 3.3 1.044e-06 3.3 1.047e-06 3.3 1.047e-06 3.3 1.05e-06 3.3 1.05e-06 3.3 1.053e-06 3.3 1.053e-06 3.3 1.056e-06 3.3 1.056e-06 3.3 1.059e-06 3.3 1.059e-06 3.3 1.062e-06 3.3 1.062e-06 3.3 1.065e-06 3.3 1.065e-06 3.3 1.068e-06 3.3 1.068e-06 3.3 1.071e-06 3.3 1.071e-06 3.3 1.074e-06 3.3 1.074e-06 3.3 1.077e-06 3.3 1.077e-06 3.3 1.08e-06 3.3 1.08e-06 3.3 1.083e-06 3.3 1.083e-06 3.3 1.086e-06 3.3 1.086e-06 3.3 1.089e-06 3.3 1.089e-06 3.3 1.092e-06 3.3 1.092e-06 3.3 1.095e-06 3.3 1.095e-06 3.3 1.098e-06 3.3 1.098e-06 3.3 1.101e-06 3.3 1.101e-06 3.3 1.104e-06 3.3 1.104e-06 0 1.107e-06 0 1.107e-06 0 1.11e-06 0 1.11e-06 0 1.113e-06 0 1.113e-06 0 1.116e-06 0 1.116e-06 0 1.119e-06 0 1.119e-06 0 1.122e-06 0 1.122e-06 0 1.125e-06 0 1.125e-06 0 1.128e-06 0 1.128e-06 0 1.131e-06 0 1.131e-06 0 1.134e-06 0 1.134e-06 0 1.137e-06 0 1.137e-06 0 1.14e-06 0 1.14e-06 0 1.143e-06 0 1.143e-06 0 1.146e-06 0 1.146e-06 0 1.149e-06 0 1.149e-06 0 1.152e-06 0 1.152e-06 0 1.155e-06 0 1.155e-06 0 1.158e-06 0 1.158e-06 0 1.161e-06 0 1.161e-06 0 1.164e-06 0 1.164e-06 0 1.167e-06 0 1.167e-06 0 1.17e-06 0 1.17e-06 0 1.173e-06 0 1.173e-06 0 1.176e-06 0 1.176e-06 0 1.179e-06 0 1.179e-06 0 1.182e-06 0 1.182e-06 0 1.185e-06 0 1.185e-06 0 1.188e-06 0 1.188e-06 0 1.191e-06 0 1.191e-06 0 1.194e-06 0 1.194e-06 0 1.197e-06 0 1.197e-06 0 1.2e-06 0 1.2e-06 3.3 1.203e-06 3.3 1.203e-06 3.3 1.206e-06 3.3 1.206e-06 3.3 1.209e-06 3.3 1.209e-06 3.3 1.212e-06 3.3 1.212e-06 3.3 1.215e-06 3.3 1.215e-06 3.3 1.218e-06 3.3 1.218e-06 3.3 1.221e-06 3.3 1.221e-06 3.3 1.224e-06 3.3 1.224e-06 3.3 1.227e-06 3.3 1.227e-06 3.3 1.23e-06 3.3 1.23e-06 3.3 1.233e-06 3.3 1.233e-06 3.3 1.236e-06 3.3 1.236e-06 3.3 1.239e-06 3.3 1.239e-06 3.3 1.242e-06 3.3 1.242e-06 3.3 1.245e-06 3.3 1.245e-06 3.3 1.248e-06 3.3 1.248e-06 3.3 1.251e-06 3.3 1.251e-06 3.3 1.254e-06 3.3 1.254e-06 3.3 1.257e-06 3.3 1.257e-06 3.3 1.26e-06 3.3 1.26e-06 3.3 1.263e-06 3.3 1.263e-06 3.3 1.266e-06 3.3 1.266e-06 3.3 1.269e-06 3.3 1.269e-06 3.3 1.272e-06 3.3 1.272e-06 3.3 1.275e-06 3.3 1.275e-06 3.3 1.278e-06 3.3 1.278e-06 3.3 1.281e-06 3.3 1.281e-06 3.3 1.284e-06 3.3 1.284e-06 3.3 1.287e-06 3.3 1.287e-06 3.3 1.29e-06 3.3 1.29e-06 3.3 1.293e-06 3.3 1.293e-06 3.3 1.296e-06 3.3 1.296e-06 0 1.299e-06 0 1.299e-06 0 1.302e-06 0 1.302e-06 0 1.305e-06 0 1.305e-06 0 1.308e-06 0 1.308e-06 0 1.311e-06 0 1.311e-06 0 1.314e-06 0 1.314e-06 0 1.317e-06 0 1.317e-06 0 1.32e-06 0 1.32e-06 0 1.323e-06 0 1.323e-06 0 1.326e-06 0 1.326e-06 0 1.329e-06 0 1.329e-06 0 1.332e-06 0 1.332e-06 0 1.335e-06 0 1.335e-06 0 1.338e-06 0 1.338e-06 0 1.341e-06 0 1.341e-06 0 1.344e-06 0 1.344e-06 0 1.347e-06 0 1.347e-06 0 1.35e-06 0 1.35e-06 0 1.353e-06 0 1.353e-06 0 1.356e-06 0 1.356e-06 0 1.359e-06 0 1.359e-06 0 1.362e-06 0 1.362e-06 0 1.365e-06 0 1.365e-06 0 1.368e-06 0 1.368e-06 0 1.371e-06 0 1.371e-06 0 1.374e-06 0 1.374e-06 0 1.377e-06 0 1.377e-06 0 1.38e-06 0 1.38e-06 0 1.383e-06 0 1.383e-06 0 1.386e-06 0 1.386e-06 0 1.389e-06 0 1.389e-06 0 1.392e-06 0 1.392e-06 3.3 1.395e-06 3.3 1.395e-06 3.3 1.398e-06 3.3 1.398e-06 3.3 1.401e-06 3.3 1.401e-06 3.3 1.404e-06 3.3 1.404e-06 3.3 1.407e-06 3.3 1.407e-06 3.3 1.41e-06 3.3 1.41e-06 3.3 1.413e-06 3.3 1.413e-06 3.3 1.416e-06 3.3 1.416e-06 3.3 1.419e-06 3.3 1.419e-06 3.3 1.422e-06 3.3 1.422e-06 3.3 1.425e-06 3.3 1.425e-06 3.3 1.428e-06 3.3 1.428e-06 3.3 1.431e-06 3.3 1.431e-06 3.3 1.434e-06 3.3 1.434e-06 3.3 1.437e-06 3.3 1.437e-06 3.3 1.44e-06 3.3 1.44e-06 3.3 1.443e-06 3.3 1.443e-06 3.3 1.446e-06 3.3 1.446e-06 3.3 1.449e-06 3.3 1.449e-06 3.3 1.452e-06 3.3 1.452e-06 3.3 1.455e-06 3.3 1.455e-06 3.3 1.458e-06 3.3 1.458e-06 3.3 1.461e-06 3.3 1.461e-06 3.3 1.464e-06 3.3 1.464e-06 3.3 1.467e-06 3.3 1.467e-06 3.3 1.47e-06 3.3 1.47e-06 3.3 1.473e-06 3.3 1.473e-06 3.3 1.476e-06 3.3 1.476e-06 3.3 1.479e-06 3.3 1.479e-06 3.3 1.482e-06 3.3 1.482e-06 3.3 1.485e-06 3.3 1.485e-06 3.3 1.488e-06 3.3 1.488e-06 0 1.491e-06 0 1.491e-06 0 1.494e-06 0 1.494e-06 0 1.497e-06 0 1.497e-06 0 1.5e-06 0 1.5e-06 0 1.503e-06 0 1.503e-06 0 1.506e-06 0 1.506e-06 0 1.509e-06 0 1.509e-06 0 1.512e-06 0 1.512e-06 0 1.515e-06 0 1.515e-06 0 1.518e-06 0 1.518e-06 0 1.521e-06 0 1.521e-06 0 1.524e-06 0 1.524e-06 0 1.527e-06 0 1.527e-06 0 1.53e-06 0 1.53e-06 0 1.533e-06 0 1.533e-06 0)
VB1 B1 0 PWL(0 0 3e-09 0 3.05e-09 0 6e-09 0 6.05e-09 0 9e-09 0 9.05e-09 0 1.2e-08 0 1.205e-08 0 1.5e-08 0 1.505e-08 0 1.8e-08 0 1.805e-08 0 2.1e-08 0 2.105e-08 0 2.4e-08 0 2.405e-08 0 2.7e-08 0 2.705e-08 0 3e-08 0 3.005e-08 0 3.3e-08 0 3.305e-08 0 3.6e-08 0 3.605e-08 0 3.9e-08 0 3.905e-08 0 4.2e-08 0 4.205e-08 0 4.5e-08 0 4.505e-08 0 4.8e-08 0 4.805e-08 0 5.1e-08 0 5.105e-08 0 5.4e-08 0 5.405e-08 0 5.7e-08 0 5.705e-08 0 6e-08 0 6.005e-08 0 6.3e-08 0 6.305e-08 0 6.6e-08 0 6.605e-08 0 6.9e-08 0 6.905e-08 0 7.2e-08 0 7.205e-08 0 7.5e-08 0 7.505e-08 0 7.8e-08 0 7.805e-08 0 8.1e-08 0 8.105e-08 0 8.4e-08 0 8.405e-08 0 8.7e-08 0 8.705e-08 0 9e-08 0 9.005e-08 0 9.3e-08 0 9.305e-08 0 9.6e-08 0 9.605e-08 3.3 9.9e-08 3.3 9.905e-08 3.3 1.02e-07 3.3 1.021e-07 3.3 1.05e-07 3.3 1.051e-07 3.3 1.08e-07 3.3 1.081e-07 3.3 1.11e-07 3.3 1.111e-07 3.3 1.14e-07 3.3 1.141e-07 3.3 1.17e-07 3.3 1.171e-07 3.3 1.2e-07 3.3 1.2e-07 3.3 1.23e-07 3.3 1.231e-07 3.3 1.26e-07 3.3 1.26e-07 3.3 1.29e-07 3.3 1.291e-07 3.3 1.32e-07 3.3 1.32e-07 3.3 1.35e-07 3.3 1.351e-07 3.3 1.38e-07 3.3 1.38e-07 3.3 1.41e-07 3.3 1.411e-07 3.3 1.44e-07 3.3 1.44e-07 3.3 1.47e-07 3.3 1.471e-07 3.3 1.5e-07 3.3 1.5e-07 3.3 1.53e-07 3.3 1.531e-07 3.3 1.56e-07 3.3 1.56e-07 3.3 1.59e-07 3.3 1.591e-07 3.3 1.62e-07 3.3 1.62e-07 3.3 1.65e-07 3.3 1.651e-07 3.3 1.68e-07 3.3 1.68e-07 3.3 1.71e-07 3.3 1.711e-07 3.3 1.74e-07 3.3 1.741e-07 3.3 1.77e-07 3.3 1.771e-07 3.3 1.8e-07 3.3 1.801e-07 3.3 1.83e-07 3.3 1.831e-07 3.3 1.86e-07 3.3 1.861e-07 3.3 1.89e-07 3.3 1.891e-07 3.3 1.92e-07 3.3 1.921e-07 3.3 1.95e-07 3.3 1.95e-07 3.3 1.98e-07 3.3 1.981e-07 3.3 2.01e-07 3.3 2.01e-07 3.3 2.04e-07 3.3 2.041e-07 3.3 2.07e-07 3.3 2.07e-07 3.3 2.1e-07 3.3 2.101e-07 3.3 2.13e-07 3.3 2.13e-07 3.3 2.16e-07 3.3 2.161e-07 3.3 2.19e-07 3.3 2.19e-07 3.3 2.22e-07 3.3 2.221e-07 3.3 2.25e-07 3.3 2.25e-07 3.3 2.28e-07 3.3 2.281e-07 3.3 2.31e-07 3.3 2.31e-07 3.3 2.34e-07 3.3 2.341e-07 3.3 2.37e-07 3.3 2.37e-07 3.3 2.4e-07 3.3 2.4e-07 3.3 2.43e-07 3.3 2.43e-07 3.3 2.46e-07 3.3 2.461e-07 3.3 2.49e-07 3.3 2.491e-07 3.3 2.52e-07 3.3 2.52e-07 3.3 2.55e-07 3.3 2.55e-07 3.3 2.58e-07 3.3 2.581e-07 3.3 2.61e-07 3.3 2.611e-07 3.3 2.64e-07 3.3 2.64e-07 3.3 2.67e-07 3.3 2.67e-07 3.3 2.7e-07 3.3 2.701e-07 3.3 2.73e-07 3.3 2.731e-07 3.3 2.76e-07 3.3 2.76e-07 3.3 2.79e-07 3.3 2.791e-07 3.3 2.82e-07 3.3 2.821e-07 3.3 2.85e-07 3.3 2.851e-07 3.3 2.88e-07 3.3 2.88e-07 0 2.91e-07 0 2.911e-07 0 2.94e-07 0 2.941e-07 0 2.97e-07 0 2.97e-07 0 3e-07 0 3e-07 0 3.03e-07 0 3.031e-07 0 3.06e-07 0 3.061e-07 0 3.09e-07 0 3.09e-07 0 3.12e-07 0 3.12e-07 0 3.15e-07 0 3.151e-07 0 3.18e-07 0 3.181e-07 0 3.21e-07 0 3.21e-07 0 3.24e-07 0 3.24e-07 0 3.27e-07 0 3.271e-07 0 3.3e-07 0 3.301e-07 0 3.33e-07 0 3.33e-07 0 3.36e-07 0 3.36e-07 0 3.39e-07 0 3.391e-07 0 3.42e-07 0 3.421e-07 0 3.45e-07 0 3.45e-07 0 3.48e-07 0 3.48e-07 0 3.51e-07 0 3.511e-07 0 3.54e-07 0 3.541e-07 0 3.57e-07 0 3.57e-07 0 3.6e-07 0 3.6e-07 0 3.63e-07 0 3.631e-07 0 3.66e-07 0 3.661e-07 0 3.69e-07 0 3.69e-07 0 3.72e-07 0 3.72e-07 0 3.75e-07 0 3.751e-07 0 3.78e-07 0 3.781e-07 0 3.81e-07 0 3.81e-07 0 3.84e-07 0 3.841e-07 0 3.87e-07 0 3.871e-07 0 3.9e-07 0 3.9e-07 0 3.93e-07 0 3.93e-07 0 3.96e-07 0 3.961e-07 0 3.99e-07 0 3.991e-07 0 4.02e-07 0 4.02e-07 0 4.05e-07 0 4.05e-07 0 4.08e-07 0 4.081e-07 0 4.11e-07 0 4.111e-07 0 4.14e-07 0 4.14e-07 0 4.17e-07 0 4.17e-07 0 4.2e-07 0 4.201e-07 0 4.23e-07 0 4.231e-07 0 4.26e-07 0 4.26e-07 0 4.29e-07 0 4.29e-07 0 4.32e-07 0 4.321e-07 0 4.35e-07 0 4.351e-07 0 4.38e-07 0 4.38e-07 0 4.41e-07 0 4.41e-07 0 4.44e-07 0 4.441e-07 0 4.47e-07 0 4.471e-07 0 4.5e-07 0 4.5e-07 0 4.53e-07 0 4.53e-07 0 4.56e-07 0 4.561e-07 0 4.59e-07 0 4.591e-07 0 4.62e-07 0 4.62e-07 0 4.65e-07 0 4.65e-07 0 4.68e-07 0 4.681e-07 0 4.71e-07 0 4.711e-07 0 4.74e-07 0 4.74e-07 0 4.77e-07 0 4.771e-07 0 4.8e-07 0 4.8e-07 3.3 4.83e-07 3.3 4.83e-07 3.3 4.86e-07 3.3 4.86e-07 3.3 4.89e-07 3.3 4.891e-07 3.3 4.92e-07 3.3 4.921e-07 3.3 4.95e-07 3.3 4.951e-07 3.3 4.98e-07 3.3 4.981e-07 3.3 5.01e-07 3.3 5.01e-07 3.3 5.04e-07 3.3 5.04e-07 3.3 5.07e-07 3.3 5.07e-07 3.3 5.1e-07 3.3 5.1e-07 3.3 5.13e-07 3.3 5.131e-07 3.3 5.16e-07 3.3 5.161e-07 3.3 5.19e-07 3.3 5.191e-07 3.3 5.22e-07 3.3 5.221e-07 3.3 5.25e-07 3.3 5.25e-07 3.3 5.28e-07 3.3 5.28e-07 3.3 5.31e-07 3.3 5.31e-07 3.3 5.34e-07 3.3 5.34e-07 3.3 5.37e-07 3.3 5.371e-07 3.3 5.4e-07 3.3 5.401e-07 3.3 5.43e-07 3.3 5.431e-07 3.3 5.46e-07 3.3 5.461e-07 3.3 5.49e-07 3.3 5.49e-07 3.3 5.52e-07 3.3 5.52e-07 3.3 5.55e-07 3.3 5.55e-07 3.3 5.58e-07 3.3 5.58e-07 3.3 5.61e-07 3.3 5.611e-07 3.3 5.64e-07 3.3 5.641e-07 3.3 5.67e-07 3.3 5.671e-07 3.3 5.7e-07 3.3 5.701e-07 3.3 5.73e-07 3.3 5.73e-07 3.3 5.76e-07 3.3 5.76e-07 3.3 5.79e-07 3.3 5.79e-07 3.3 5.82e-07 3.3 5.821e-07 3.3 5.85e-07 3.3 5.851e-07 3.3 5.88e-07 3.3 5.881e-07 3.3 5.91e-07 3.3 5.911e-07 3.3 5.94e-07 3.3 5.94e-07 3.3 5.97e-07 3.3 5.97e-07 3.3 6e-07 3.3 6e-07 3.3 6.03e-07 3.3 6.03e-07 3.3 6.06e-07 3.3 6.061e-07 3.3 6.09e-07 3.3 6.091e-07 3.3 6.12e-07 3.3 6.121e-07 3.3 6.15e-07 3.3 6.151e-07 3.3 6.18e-07 3.3 6.18e-07 3.3 6.21e-07 3.3 6.21e-07 3.3 6.24e-07 3.3 6.24e-07 3.3 6.27e-07 3.3 6.27e-07 3.3 6.3e-07 3.3 6.301e-07 3.3 6.33e-07 3.3 6.331e-07 3.3 6.36e-07 3.3 6.361e-07 3.3 6.39e-07 3.3 6.391e-07 3.3 6.42e-07 3.3 6.42e-07 3.3 6.45e-07 3.3 6.45e-07 3.3 6.48e-07 3.3 6.48e-07 3.3 6.51e-07 3.3 6.51e-07 3.3 6.54e-07 3.3 6.541e-07 3.3 6.57e-07 3.3 6.571e-07 3.3 6.6e-07 3.3 6.601e-07 3.3 6.63e-07 3.3 6.631e-07 3.3 6.66e-07 3.3 6.66e-07 3.3 6.69e-07 3.3 6.69e-07 3.3 6.72e-07 3.3 6.72e-07 0 6.75e-07 0 6.75e-07 0 6.78e-07 0 6.781e-07 0 6.81e-07 0 6.811e-07 0 6.84e-07 0 6.841e-07 0 6.87e-07 0 6.87e-07 0 6.9e-07 0 6.9e-07 0 6.93e-07 0 6.93e-07 0 6.96e-07 0 6.96e-07 0 6.99e-07 0 6.991e-07 0 7.02e-07 0 7.021e-07 0 7.05e-07 0 7.051e-07 0 7.08e-07 0 7.081e-07 0 7.11e-07 0 7.11e-07 0 7.14e-07 0 7.14e-07 0 7.17e-07 0 7.17e-07 0 7.2e-07 0 7.2e-07 0 7.23e-07 0 7.231e-07 0 7.26e-07 0 7.261e-07 0 7.29e-07 0 7.291e-07 0 7.32e-07 0 7.321e-07 0 7.35e-07 0 7.35e-07 0 7.38e-07 0 7.38e-07 0 7.41e-07 0 7.41e-07 0 7.44e-07 0 7.44e-07 0 7.47e-07 0 7.471e-07 0 7.5e-07 0 7.501e-07 0 7.53e-07 0 7.531e-07 0 7.56e-07 0 7.561e-07 0 7.59e-07 0 7.59e-07 0 7.62e-07 0 7.62e-07 0 7.65e-07 0 7.65e-07 0 7.68e-07 0 7.68e-07 0 7.71e-07 0 7.711e-07 0 7.74e-07 0 7.741e-07 0 7.77e-07 0 7.771e-07 0 7.8e-07 0 7.8e-07 0 7.83e-07 0 7.83e-07 0 7.86e-07 0 7.86e-07 0 7.89e-07 0 7.89e-07 0 7.92e-07 0 7.921e-07 0 7.95e-07 0 7.951e-07 0 7.98e-07 0 7.981e-07 0 8.01e-07 0 8.011e-07 0 8.04e-07 0 8.04e-07 0 8.07e-07 0 8.07e-07 0 8.1e-07 0 8.1e-07 0 8.13e-07 0 8.13e-07 0 8.16e-07 0 8.161e-07 0 8.19e-07 0 8.191e-07 0 8.22e-07 0 8.221e-07 0 8.25e-07 0 8.251e-07 0 8.28e-07 0 8.28e-07 0 8.31e-07 0 8.31e-07 0 8.34e-07 0 8.34e-07 0 8.37e-07 0 8.37e-07 0 8.4e-07 0 8.401e-07 0 8.43e-07 0 8.431e-07 0 8.46e-07 0 8.461e-07 0 8.49e-07 0 8.491e-07 0 8.52e-07 0 8.52e-07 0 8.55e-07 0 8.55e-07 0 8.58e-07 0 8.58e-07 0 8.61e-07 0 8.61e-07 0 8.64e-07 0 8.641e-07 3.3 8.67e-07 3.3 8.671e-07 3.3 8.7e-07 3.3 8.701e-07 3.3 8.73e-07 3.3 8.73e-07 3.3 8.76e-07 3.3 8.76e-07 3.3 8.79e-07 3.3 8.79e-07 3.3 8.82e-07 3.3 8.82e-07 3.3 8.85e-07 3.3 8.851e-07 3.3 8.88e-07 3.3 8.881e-07 3.3 8.91e-07 3.3 8.911e-07 3.3 8.94e-07 3.3 8.941e-07 3.3 8.97e-07 3.3 8.97e-07 3.3 9e-07 3.3 9e-07 3.3 9.03e-07 3.3 9.03e-07 3.3 9.06e-07 3.3 9.06e-07 3.3 9.09e-07 3.3 9.091e-07 3.3 9.12e-07 3.3 9.121e-07 3.3 9.15e-07 3.3 9.151e-07 3.3 9.18e-07 3.3 9.181e-07 3.3 9.21e-07 3.3 9.21e-07 3.3 9.24e-07 3.3 9.24e-07 3.3 9.27e-07 3.3 9.27e-07 3.3 9.3e-07 3.3 9.3e-07 3.3 9.33e-07 3.3 9.331e-07 3.3 9.36e-07 3.3 9.361e-07 3.3 9.39e-07 3.3 9.391e-07 3.3 9.42e-07 3.3 9.421e-07 3.3 9.45e-07 3.3 9.45e-07 3.3 9.48e-07 3.3 9.48e-07 3.3 9.51e-07 3.3 9.51e-07 3.3 9.54e-07 3.3 9.54e-07 3.3 9.57e-07 3.3 9.57e-07 3.3 9.6e-07 3.3 9.6e-07 3.3 9.63e-07 3.3 9.63e-07 3.3 9.66e-07 3.3 9.66e-07 3.3 9.69e-07 3.3 9.69e-07 3.3 9.72e-07 3.3 9.72e-07 3.3 9.75e-07 3.3 9.75e-07 3.3 9.78e-07 3.3 9.78e-07 3.3 9.81e-07 3.3 9.81e-07 3.3 9.84e-07 3.3 9.84e-07 3.3 9.87e-07 3.3 9.87e-07 3.3 9.9e-07 3.3 9.9e-07 3.3 9.93e-07 3.3 9.93e-07 3.3 9.96e-07 3.3 9.96e-07 3.3 9.99e-07 3.3 9.99e-07 3.3 1.002e-06 3.3 1.002e-06 3.3 1.005e-06 3.3 1.005e-06 3.3 1.008e-06 3.3 1.008e-06 3.3 1.011e-06 3.3 1.011e-06 3.3 1.014e-06 3.3 1.014e-06 3.3 1.017e-06 3.3 1.017e-06 3.3 1.02e-06 3.3 1.02e-06 3.3 1.023e-06 3.3 1.023e-06 3.3 1.026e-06 3.3 1.026e-06 3.3 1.029e-06 3.3 1.029e-06 3.3 1.032e-06 3.3 1.032e-06 3.3 1.035e-06 3.3 1.035e-06 3.3 1.038e-06 3.3 1.038e-06 3.3 1.041e-06 3.3 1.041e-06 3.3 1.044e-06 3.3 1.044e-06 3.3 1.047e-06 3.3 1.047e-06 3.3 1.05e-06 3.3 1.05e-06 3.3 1.053e-06 3.3 1.053e-06 3.3 1.056e-06 3.3 1.056e-06 0 1.059e-06 0 1.059e-06 0 1.062e-06 0 1.062e-06 0 1.065e-06 0 1.065e-06 0 1.068e-06 0 1.068e-06 0 1.071e-06 0 1.071e-06 0 1.074e-06 0 1.074e-06 0 1.077e-06 0 1.077e-06 0 1.08e-06 0 1.08e-06 0 1.083e-06 0 1.083e-06 0 1.086e-06 0 1.086e-06 0 1.089e-06 0 1.089e-06 0 1.092e-06 0 1.092e-06 0 1.095e-06 0 1.095e-06 0 1.098e-06 0 1.098e-06 0 1.101e-06 0 1.101e-06 0 1.104e-06 0 1.104e-06 0 1.107e-06 0 1.107e-06 0 1.11e-06 0 1.11e-06 0 1.113e-06 0 1.113e-06 0 1.116e-06 0 1.116e-06 0 1.119e-06 0 1.119e-06 0 1.122e-06 0 1.122e-06 0 1.125e-06 0 1.125e-06 0 1.128e-06 0 1.128e-06 0 1.131e-06 0 1.131e-06 0 1.134e-06 0 1.134e-06 0 1.137e-06 0 1.137e-06 0 1.14e-06 0 1.14e-06 0 1.143e-06 0 1.143e-06 0 1.146e-06 0 1.146e-06 0 1.149e-06 0 1.149e-06 0 1.152e-06 0 1.152e-06 0 1.155e-06 0 1.155e-06 0 1.158e-06 0 1.158e-06 0 1.161e-06 0 1.161e-06 0 1.164e-06 0 1.164e-06 0 1.167e-06 0 1.167e-06 0 1.17e-06 0 1.17e-06 0 1.173e-06 0 1.173e-06 0 1.176e-06 0 1.176e-06 0 1.179e-06 0 1.179e-06 0 1.182e-06 0 1.182e-06 0 1.185e-06 0 1.185e-06 0 1.188e-06 0 1.188e-06 0 1.191e-06 0 1.191e-06 0 1.194e-06 0 1.194e-06 0 1.197e-06 0 1.197e-06 0 1.2e-06 0 1.2e-06 0 1.203e-06 0 1.203e-06 0 1.206e-06 0 1.206e-06 0 1.209e-06 0 1.209e-06 0 1.212e-06 0 1.212e-06 0 1.215e-06 0 1.215e-06 0 1.218e-06 0 1.218e-06 0 1.221e-06 0 1.221e-06 0 1.224e-06 0 1.224e-06 0 1.227e-06 0 1.227e-06 0 1.23e-06 0 1.23e-06 0 1.233e-06 0 1.233e-06 0 1.236e-06 0 1.236e-06 0 1.239e-06 0 1.239e-06 0 1.242e-06 0 1.242e-06 0 1.245e-06 0 1.245e-06 0 1.248e-06 0 1.248e-06 3.3 1.251e-06 3.3 1.251e-06 3.3 1.254e-06 3.3 1.254e-06 3.3 1.257e-06 3.3 1.257e-06 3.3 1.26e-06 3.3 1.26e-06 3.3 1.263e-06 3.3 1.263e-06 3.3 1.266e-06 3.3 1.266e-06 3.3 1.269e-06 3.3 1.269e-06 3.3 1.272e-06 3.3 1.272e-06 3.3 1.275e-06 3.3 1.275e-06 3.3 1.278e-06 3.3 1.278e-06 3.3 1.281e-06 3.3 1.281e-06 3.3 1.284e-06 3.3 1.284e-06 3.3 1.287e-06 3.3 1.287e-06 3.3 1.29e-06 3.3 1.29e-06 3.3 1.293e-06 3.3 1.293e-06 3.3 1.296e-06 3.3 1.296e-06 3.3 1.299e-06 3.3 1.299e-06 3.3 1.302e-06 3.3 1.302e-06 3.3 1.305e-06 3.3 1.305e-06 3.3 1.308e-06 3.3 1.308e-06 3.3 1.311e-06 3.3 1.311e-06 3.3 1.314e-06 3.3 1.314e-06 3.3 1.317e-06 3.3 1.317e-06 3.3 1.32e-06 3.3 1.32e-06 3.3 1.323e-06 3.3 1.323e-06 3.3 1.326e-06 3.3 1.326e-06 3.3 1.329e-06 3.3 1.329e-06 3.3 1.332e-06 3.3 1.332e-06 3.3 1.335e-06 3.3 1.335e-06 3.3 1.338e-06 3.3 1.338e-06 3.3 1.341e-06 3.3 1.341e-06 3.3 1.344e-06 3.3 1.344e-06 3.3 1.347e-06 3.3 1.347e-06 3.3 1.35e-06 3.3 1.35e-06 3.3 1.353e-06 3.3 1.353e-06 3.3 1.356e-06 3.3 1.356e-06 3.3 1.359e-06 3.3 1.359e-06 3.3 1.362e-06 3.3 1.362e-06 3.3 1.365e-06 3.3 1.365e-06 3.3 1.368e-06 3.3 1.368e-06 3.3 1.371e-06 3.3 1.371e-06 3.3 1.374e-06 3.3 1.374e-06 3.3 1.377e-06 3.3 1.377e-06 3.3 1.38e-06 3.3 1.38e-06 3.3 1.383e-06 3.3 1.383e-06 3.3 1.386e-06 3.3 1.386e-06 3.3 1.389e-06 3.3 1.389e-06 3.3 1.392e-06 3.3 1.392e-06 3.3 1.395e-06 3.3 1.395e-06 3.3 1.398e-06 3.3 1.398e-06 3.3 1.401e-06 3.3 1.401e-06 3.3 1.404e-06 3.3 1.404e-06 3.3 1.407e-06 3.3 1.407e-06 3.3 1.41e-06 3.3 1.41e-06 3.3 1.413e-06 3.3 1.413e-06 3.3 1.416e-06 3.3 1.416e-06 3.3 1.419e-06 3.3 1.419e-06 3.3 1.422e-06 3.3 1.422e-06 3.3 1.425e-06 3.3 1.425e-06 3.3 1.428e-06 3.3 1.428e-06 3.3 1.431e-06 3.3 1.431e-06 3.3 1.434e-06 3.3 1.434e-06 3.3 1.437e-06 3.3 1.437e-06 3.3 1.44e-06 3.3 1.44e-06 0 1.443e-06 0 1.443e-06 0 1.446e-06 0 1.446e-06 0 1.449e-06 0 1.449e-06 0 1.452e-06 0 1.452e-06 0 1.455e-06 0 1.455e-06 0 1.458e-06 0 1.458e-06 0 1.461e-06 0 1.461e-06 0 1.464e-06 0 1.464e-06 0 1.467e-06 0 1.467e-06 0 1.47e-06 0 1.47e-06 0 1.473e-06 0 1.473e-06 0 1.476e-06 0 1.476e-06 0 1.479e-06 0 1.479e-06 0 1.482e-06 0 1.482e-06 0 1.485e-06 0 1.485e-06 0 1.488e-06 0 1.488e-06 0 1.491e-06 0 1.491e-06 0 1.494e-06 0 1.494e-06 0 1.497e-06 0 1.497e-06 0 1.5e-06 0 1.5e-06 0 1.503e-06 0 1.503e-06 0 1.506e-06 0 1.506e-06 0 1.509e-06 0 1.509e-06 0 1.512e-06 0 1.512e-06 0 1.515e-06 0 1.515e-06 0 1.518e-06 0 1.518e-06 0 1.521e-06 0 1.521e-06 0 1.524e-06 0 1.524e-06 0 1.527e-06 0 1.527e-06 0 1.53e-06 0 1.53e-06 0 1.533e-06 0 1.533e-06 0)
VB2 B2 0 PWL(0 0 3e-09 0 3.05e-09 0 6e-09 0 6.05e-09 0 9e-09 0 9.05e-09 0 1.2e-08 0 1.205e-08 0 1.5e-08 0 1.505e-08 0 1.8e-08 0 1.805e-08 0 2.1e-08 0 2.105e-08 0 2.4e-08 0 2.405e-08 0 2.7e-08 0 2.705e-08 0 3e-08 0 3.005e-08 0 3.3e-08 0 3.305e-08 0 3.6e-08 0 3.605e-08 0 3.9e-08 0 3.905e-08 0 4.2e-08 0 4.205e-08 0 4.5e-08 0 4.505e-08 0 4.8e-08 0 4.805e-08 0 5.1e-08 0 5.105e-08 0 5.4e-08 0 5.405e-08 0 5.7e-08 0 5.705e-08 0 6e-08 0 6.005e-08 0 6.3e-08 0 6.305e-08 0 6.6e-08 0 6.605e-08 0 6.9e-08 0 6.905e-08 0 7.2e-08 0 7.205e-08 0 7.5e-08 0 7.505e-08 0 7.8e-08 0 7.805e-08 0 8.1e-08 0 8.105e-08 0 8.4e-08 0 8.405e-08 0 8.7e-08 0 8.705e-08 0 9e-08 0 9.005e-08 0 9.3e-08 0 9.305e-08 0 9.6e-08 0 9.605e-08 0 9.9e-08 0 9.905e-08 0 1.02e-07 0 1.021e-07 0 1.05e-07 0 1.051e-07 0 1.08e-07 0 1.081e-07 0 1.11e-07 0 1.111e-07 0 1.14e-07 0 1.141e-07 0 1.17e-07 0 1.171e-07 0 1.2e-07 0 1.2e-07 0 1.23e-07 0 1.231e-07 0 1.26e-07 0 1.26e-07 0 1.29e-07 0 1.291e-07 0 1.32e-07 0 1.32e-07 0 1.35e-07 0 1.351e-07 0 1.38e-07 0 1.38e-07 0 1.41e-07 0 1.411e-07 0 1.44e-07 0 1.44e-07 0 1.47e-07 0 1.471e-07 0 1.5e-07 0 1.5e-07 0 1.53e-07 0 1.531e-07 0 1.56e-07 0 1.56e-07 0 1.59e-07 0 1.591e-07 0 1.62e-07 0 1.62e-07 0 1.65e-07 0 1.651e-07 0 1.68e-07 0 1.68e-07 0 1.71e-07 0 1.711e-07 0 1.74e-07 0 1.741e-07 0 1.77e-07 0 1.771e-07 0 1.8e-07 0 1.801e-07 0 1.83e-07 0 1.831e-07 0 1.86e-07 0 1.861e-07 0 1.89e-07 0 1.891e-07 0 1.92e-07 0 1.921e-07 3.3 1.95e-07 3.3 1.95e-07 3.3 1.98e-07 3.3 1.981e-07 3.3 2.01e-07 3.3 2.01e-07 3.3 2.04e-07 3.3 2.041e-07 3.3 2.07e-07 3.3 2.07e-07 3.3 2.1e-07 3.3 2.101e-07 3.3 2.13e-07 3.3 2.13e-07 3.3 2.16e-07 3.3 2.161e-07 3.3 2.19e-07 3.3 2.19e-07 3.3 2.22e-07 3.3 2.221e-07 3.3 2.25e-07 3.3 2.25e-07 3.3 2.28e-07 3.3 2.281e-07 3.3 2.31e-07 3.3 2.31e-07 3.3 2.34e-07 3.3 2.341e-07 3.3 2.37e-07 3.3 2.37e-07 3.3 2.4e-07 3.3 2.4e-07 3.3 2.43e-07 3.3 2.43e-07 3.3 2.46e-07 3.3 2.461e-07 3.3 2.49e-07 3.3 2.491e-07 3.3 2.52e-07 3.3 2.52e-07 3.3 2.55e-07 3.3 2.55e-07 3.3 2.58e-07 3.3 2.581e-07 3.3 2.61e-07 3.3 2.611e-07 3.3 2.64e-07 3.3 2.64e-07 3.3 2.67e-07 3.3 2.67e-07 3.3 2.7e-07 3.3 2.701e-07 3.3 2.73e-07 3.3 2.731e-07 3.3 2.76e-07 3.3 2.76e-07 3.3 2.79e-07 3.3 2.791e-07 3.3 2.82e-07 3.3 2.821e-07 3.3 2.85e-07 3.3 2.851e-07 3.3 2.88e-07 3.3 2.88e-07 3.3 2.91e-07 3.3 2.911e-07 3.3 2.94e-07 3.3 2.941e-07 3.3 2.97e-07 3.3 2.97e-07 3.3 3e-07 3.3 3e-07 3.3 3.03e-07 3.3 3.031e-07 3.3 3.06e-07 3.3 3.061e-07 3.3 3.09e-07 3.3 3.09e-07 3.3 3.12e-07 3.3 3.12e-07 3.3 3.15e-07 3.3 3.151e-07 3.3 3.18e-07 3.3 3.181e-07 3.3 3.21e-07 3.3 3.21e-07 3.3 3.24e-07 3.3 3.24e-07 3.3 3.27e-07 3.3 3.271e-07 3.3 3.3e-07 3.3 3.301e-07 3.3 3.33e-07 3.3 3.33e-07 3.3 3.36e-07 3.3 3.36e-07 3.3 3.39e-07 3.3 3.391e-07 3.3 3.42e-07 3.3 3.421e-07 3.3 3.45e-07 3.3 3.45e-07 3.3 3.48e-07 3.3 3.48e-07 3.3 3.51e-07 3.3 3.511e-07 3.3 3.54e-07 3.3 3.541e-07 3.3 3.57e-07 3.3 3.57e-07 3.3 3.6e-07 3.3 3.6e-07 3.3 3.63e-07 3.3 3.631e-07 3.3 3.66e-07 3.3 3.661e-07 3.3 3.69e-07 3.3 3.69e-07 3.3 3.72e-07 3.3 3.72e-07 3.3 3.75e-07 3.3 3.751e-07 3.3 3.78e-07 3.3 3.781e-07 3.3 3.81e-07 3.3 3.81e-07 3.3 3.84e-07 3.3 3.841e-07 3.3 3.87e-07 3.3 3.871e-07 3.3 3.9e-07 3.3 3.9e-07 3.3 3.93e-07 3.3 3.93e-07 3.3 3.96e-07 3.3 3.961e-07 3.3 3.99e-07 3.3 3.991e-07 3.3 4.02e-07 3.3 4.02e-07 3.3 4.05e-07 3.3 4.05e-07 3.3 4.08e-07 3.3 4.081e-07 3.3 4.11e-07 3.3 4.111e-07 3.3 4.14e-07 3.3 4.14e-07 3.3 4.17e-07 3.3 4.17e-07 3.3 4.2e-07 3.3 4.201e-07 3.3 4.23e-07 3.3 4.231e-07 3.3 4.26e-07 3.3 4.26e-07 3.3 4.29e-07 3.3 4.29e-07 3.3 4.32e-07 3.3 4.321e-07 3.3 4.35e-07 3.3 4.351e-07 3.3 4.38e-07 3.3 4.38e-07 3.3 4.41e-07 3.3 4.41e-07 3.3 4.44e-07 3.3 4.441e-07 3.3 4.47e-07 3.3 4.471e-07 3.3 4.5e-07 3.3 4.5e-07 3.3 4.53e-07 3.3 4.53e-07 3.3 4.56e-07 3.3 4.561e-07 3.3 4.59e-07 3.3 4.591e-07 3.3 4.62e-07 3.3 4.62e-07 3.3 4.65e-07 3.3 4.65e-07 3.3 4.68e-07 3.3 4.681e-07 3.3 4.71e-07 3.3 4.711e-07 3.3 4.74e-07 3.3 4.74e-07 3.3 4.77e-07 3.3 4.771e-07 3.3 4.8e-07 3.3 4.8e-07 3.3 4.83e-07 3.3 4.83e-07 3.3 4.86e-07 3.3 4.86e-07 3.3 4.89e-07 3.3 4.891e-07 3.3 4.92e-07 3.3 4.921e-07 3.3 4.95e-07 3.3 4.951e-07 3.3 4.98e-07 3.3 4.981e-07 3.3 5.01e-07 3.3 5.01e-07 3.3 5.04e-07 3.3 5.04e-07 3.3 5.07e-07 3.3 5.07e-07 3.3 5.1e-07 3.3 5.1e-07 3.3 5.13e-07 3.3 5.131e-07 3.3 5.16e-07 3.3 5.161e-07 3.3 5.19e-07 3.3 5.191e-07 3.3 5.22e-07 3.3 5.221e-07 3.3 5.25e-07 3.3 5.25e-07 3.3 5.28e-07 3.3 5.28e-07 3.3 5.31e-07 3.3 5.31e-07 3.3 5.34e-07 3.3 5.34e-07 3.3 5.37e-07 3.3 5.371e-07 3.3 5.4e-07 3.3 5.401e-07 3.3 5.43e-07 3.3 5.431e-07 3.3 5.46e-07 3.3 5.461e-07 3.3 5.49e-07 3.3 5.49e-07 3.3 5.52e-07 3.3 5.52e-07 3.3 5.55e-07 3.3 5.55e-07 3.3 5.58e-07 3.3 5.58e-07 3.3 5.61e-07 3.3 5.611e-07 3.3 5.64e-07 3.3 5.641e-07 3.3 5.67e-07 3.3 5.671e-07 3.3 5.7e-07 3.3 5.701e-07 3.3 5.73e-07 3.3 5.73e-07 3.3 5.76e-07 3.3 5.76e-07 0 5.79e-07 0 5.79e-07 0 5.82e-07 0 5.821e-07 0 5.85e-07 0 5.851e-07 0 5.88e-07 0 5.881e-07 0 5.91e-07 0 5.911e-07 0 5.94e-07 0 5.94e-07 0 5.97e-07 0 5.97e-07 0 6e-07 0 6e-07 0 6.03e-07 0 6.03e-07 0 6.06e-07 0 6.061e-07 0 6.09e-07 0 6.091e-07 0 6.12e-07 0 6.121e-07 0 6.15e-07 0 6.151e-07 0 6.18e-07 0 6.18e-07 0 6.21e-07 0 6.21e-07 0 6.24e-07 0 6.24e-07 0 6.27e-07 0 6.27e-07 0 6.3e-07 0 6.301e-07 0 6.33e-07 0 6.331e-07 0 6.36e-07 0 6.361e-07 0 6.39e-07 0 6.391e-07 0 6.42e-07 0 6.42e-07 0 6.45e-07 0 6.45e-07 0 6.48e-07 0 6.48e-07 0 6.51e-07 0 6.51e-07 0 6.54e-07 0 6.541e-07 0 6.57e-07 0 6.571e-07 0 6.6e-07 0 6.601e-07 0 6.63e-07 0 6.631e-07 0 6.66e-07 0 6.66e-07 0 6.69e-07 0 6.69e-07 0 6.72e-07 0 6.72e-07 0 6.75e-07 0 6.75e-07 0 6.78e-07 0 6.781e-07 0 6.81e-07 0 6.811e-07 0 6.84e-07 0 6.841e-07 0 6.87e-07 0 6.87e-07 0 6.9e-07 0 6.9e-07 0 6.93e-07 0 6.93e-07 0 6.96e-07 0 6.96e-07 0 6.99e-07 0 6.991e-07 0 7.02e-07 0 7.021e-07 0 7.05e-07 0 7.051e-07 0 7.08e-07 0 7.081e-07 0 7.11e-07 0 7.11e-07 0 7.14e-07 0 7.14e-07 0 7.17e-07 0 7.17e-07 0 7.2e-07 0 7.2e-07 0 7.23e-07 0 7.231e-07 0 7.26e-07 0 7.261e-07 0 7.29e-07 0 7.291e-07 0 7.32e-07 0 7.321e-07 0 7.35e-07 0 7.35e-07 0 7.38e-07 0 7.38e-07 0 7.41e-07 0 7.41e-07 0 7.44e-07 0 7.44e-07 0 7.47e-07 0 7.471e-07 0 7.5e-07 0 7.501e-07 0 7.53e-07 0 7.531e-07 0 7.56e-07 0 7.561e-07 0 7.59e-07 0 7.59e-07 0 7.62e-07 0 7.62e-07 0 7.65e-07 0 7.65e-07 0 7.68e-07 0 7.68e-07 0 7.71e-07 0 7.711e-07 0 7.74e-07 0 7.741e-07 0 7.77e-07 0 7.771e-07 0 7.8e-07 0 7.8e-07 0 7.83e-07 0 7.83e-07 0 7.86e-07 0 7.86e-07 0 7.89e-07 0 7.89e-07 0 7.92e-07 0 7.921e-07 0 7.95e-07 0 7.951e-07 0 7.98e-07 0 7.981e-07 0 8.01e-07 0 8.011e-07 0 8.04e-07 0 8.04e-07 0 8.07e-07 0 8.07e-07 0 8.1e-07 0 8.1e-07 0 8.13e-07 0 8.13e-07 0 8.16e-07 0 8.161e-07 0 8.19e-07 0 8.191e-07 0 8.22e-07 0 8.221e-07 0 8.25e-07 0 8.251e-07 0 8.28e-07 0 8.28e-07 0 8.31e-07 0 8.31e-07 0 8.34e-07 0 8.34e-07 0 8.37e-07 0 8.37e-07 0 8.4e-07 0 8.401e-07 0 8.43e-07 0 8.431e-07 0 8.46e-07 0 8.461e-07 0 8.49e-07 0 8.491e-07 0 8.52e-07 0 8.52e-07 0 8.55e-07 0 8.55e-07 0 8.58e-07 0 8.58e-07 0 8.61e-07 0 8.61e-07 0 8.64e-07 0 8.641e-07 0 8.67e-07 0 8.671e-07 0 8.7e-07 0 8.701e-07 0 8.73e-07 0 8.73e-07 0 8.76e-07 0 8.76e-07 0 8.79e-07 0 8.79e-07 0 8.82e-07 0 8.82e-07 0 8.85e-07 0 8.851e-07 0 8.88e-07 0 8.881e-07 0 8.91e-07 0 8.911e-07 0 8.94e-07 0 8.941e-07 0 8.97e-07 0 8.97e-07 0 9e-07 0 9e-07 0 9.03e-07 0 9.03e-07 0 9.06e-07 0 9.06e-07 0 9.09e-07 0 9.091e-07 0 9.12e-07 0 9.121e-07 0 9.15e-07 0 9.151e-07 0 9.18e-07 0 9.181e-07 0 9.21e-07 0 9.21e-07 0 9.24e-07 0 9.24e-07 0 9.27e-07 0 9.27e-07 0 9.3e-07 0 9.3e-07 0 9.33e-07 0 9.331e-07 0 9.36e-07 0 9.361e-07 0 9.39e-07 0 9.391e-07 0 9.42e-07 0 9.421e-07 0 9.45e-07 0 9.45e-07 0 9.48e-07 0 9.48e-07 0 9.51e-07 0 9.51e-07 0 9.54e-07 0 9.54e-07 0 9.57e-07 0 9.57e-07 0 9.6e-07 0 9.6e-07 3.3 9.63e-07 3.3 9.63e-07 3.3 9.66e-07 3.3 9.66e-07 3.3 9.69e-07 3.3 9.69e-07 3.3 9.72e-07 3.3 9.72e-07 3.3 9.75e-07 3.3 9.75e-07 3.3 9.78e-07 3.3 9.78e-07 3.3 9.81e-07 3.3 9.81e-07 3.3 9.84e-07 3.3 9.84e-07 3.3 9.87e-07 3.3 9.87e-07 3.3 9.9e-07 3.3 9.9e-07 3.3 9.93e-07 3.3 9.93e-07 3.3 9.96e-07 3.3 9.96e-07 3.3 9.99e-07 3.3 9.99e-07 3.3 1.002e-06 3.3 1.002e-06 3.3 1.005e-06 3.3 1.005e-06 3.3 1.008e-06 3.3 1.008e-06 3.3 1.011e-06 3.3 1.011e-06 3.3 1.014e-06 3.3 1.014e-06 3.3 1.017e-06 3.3 1.017e-06 3.3 1.02e-06 3.3 1.02e-06 3.3 1.023e-06 3.3 1.023e-06 3.3 1.026e-06 3.3 1.026e-06 3.3 1.029e-06 3.3 1.029e-06 3.3 1.032e-06 3.3 1.032e-06 3.3 1.035e-06 3.3 1.035e-06 3.3 1.038e-06 3.3 1.038e-06 3.3 1.041e-06 3.3 1.041e-06 3.3 1.044e-06 3.3 1.044e-06 3.3 1.047e-06 3.3 1.047e-06 3.3 1.05e-06 3.3 1.05e-06 3.3 1.053e-06 3.3 1.053e-06 3.3 1.056e-06 3.3 1.056e-06 3.3 1.059e-06 3.3 1.059e-06 3.3 1.062e-06 3.3 1.062e-06 3.3 1.065e-06 3.3 1.065e-06 3.3 1.068e-06 3.3 1.068e-06 3.3 1.071e-06 3.3 1.071e-06 3.3 1.074e-06 3.3 1.074e-06 3.3 1.077e-06 3.3 1.077e-06 3.3 1.08e-06 3.3 1.08e-06 3.3 1.083e-06 3.3 1.083e-06 3.3 1.086e-06 3.3 1.086e-06 3.3 1.089e-06 3.3 1.089e-06 3.3 1.092e-06 3.3 1.092e-06 3.3 1.095e-06 3.3 1.095e-06 3.3 1.098e-06 3.3 1.098e-06 3.3 1.101e-06 3.3 1.101e-06 3.3 1.104e-06 3.3 1.104e-06 3.3 1.107e-06 3.3 1.107e-06 3.3 1.11e-06 3.3 1.11e-06 3.3 1.113e-06 3.3 1.113e-06 3.3 1.116e-06 3.3 1.116e-06 3.3 1.119e-06 3.3 1.119e-06 3.3 1.122e-06 3.3 1.122e-06 3.3 1.125e-06 3.3 1.125e-06 3.3 1.128e-06 3.3 1.128e-06 3.3 1.131e-06 3.3 1.131e-06 3.3 1.134e-06 3.3 1.134e-06 3.3 1.137e-06 3.3 1.137e-06 3.3 1.14e-06 3.3 1.14e-06 3.3 1.143e-06 3.3 1.143e-06 3.3 1.146e-06 3.3 1.146e-06 3.3 1.149e-06 3.3 1.149e-06 3.3 1.152e-06 3.3 1.152e-06 3.3 1.155e-06 3.3 1.155e-06 3.3 1.158e-06 3.3 1.158e-06 3.3 1.161e-06 3.3 1.161e-06 3.3 1.164e-06 3.3 1.164e-06 3.3 1.167e-06 3.3 1.167e-06 3.3 1.17e-06 3.3 1.17e-06 3.3 1.173e-06 3.3 1.173e-06 3.3 1.176e-06 3.3 1.176e-06 3.3 1.179e-06 3.3 1.179e-06 3.3 1.182e-06 3.3 1.182e-06 3.3 1.185e-06 3.3 1.185e-06 3.3 1.188e-06 3.3 1.188e-06 3.3 1.191e-06 3.3 1.191e-06 3.3 1.194e-06 3.3 1.194e-06 3.3 1.197e-06 3.3 1.197e-06 3.3 1.2e-06 3.3 1.2e-06 3.3 1.203e-06 3.3 1.203e-06 3.3 1.206e-06 3.3 1.206e-06 3.3 1.209e-06 3.3 1.209e-06 3.3 1.212e-06 3.3 1.212e-06 3.3 1.215e-06 3.3 1.215e-06 3.3 1.218e-06 3.3 1.218e-06 3.3 1.221e-06 3.3 1.221e-06 3.3 1.224e-06 3.3 1.224e-06 3.3 1.227e-06 3.3 1.227e-06 3.3 1.23e-06 3.3 1.23e-06 3.3 1.233e-06 3.3 1.233e-06 3.3 1.236e-06 3.3 1.236e-06 3.3 1.239e-06 3.3 1.239e-06 3.3 1.242e-06 3.3 1.242e-06 3.3 1.245e-06 3.3 1.245e-06 3.3 1.248e-06 3.3 1.248e-06 3.3 1.251e-06 3.3 1.251e-06 3.3 1.254e-06 3.3 1.254e-06 3.3 1.257e-06 3.3 1.257e-06 3.3 1.26e-06 3.3 1.26e-06 3.3 1.263e-06 3.3 1.263e-06 3.3 1.266e-06 3.3 1.266e-06 3.3 1.269e-06 3.3 1.269e-06 3.3 1.272e-06 3.3 1.272e-06 3.3 1.275e-06 3.3 1.275e-06 3.3 1.278e-06 3.3 1.278e-06 3.3 1.281e-06 3.3 1.281e-06 3.3 1.284e-06 3.3 1.284e-06 3.3 1.287e-06 3.3 1.287e-06 3.3 1.29e-06 3.3 1.29e-06 3.3 1.293e-06 3.3 1.293e-06 3.3 1.296e-06 3.3 1.296e-06 3.3 1.299e-06 3.3 1.299e-06 3.3 1.302e-06 3.3 1.302e-06 3.3 1.305e-06 3.3 1.305e-06 3.3 1.308e-06 3.3 1.308e-06 3.3 1.311e-06 3.3 1.311e-06 3.3 1.314e-06 3.3 1.314e-06 3.3 1.317e-06 3.3 1.317e-06 3.3 1.32e-06 3.3 1.32e-06 3.3 1.323e-06 3.3 1.323e-06 3.3 1.326e-06 3.3 1.326e-06 3.3 1.329e-06 3.3 1.329e-06 3.3 1.332e-06 3.3 1.332e-06 3.3 1.335e-06 3.3 1.335e-06 3.3 1.338e-06 3.3 1.338e-06 3.3 1.341e-06 3.3 1.341e-06 3.3 1.344e-06 3.3 1.344e-06 0 1.347e-06 0 1.347e-06 0 1.35e-06 0 1.35e-06 0 1.353e-06 0 1.353e-06 0 1.356e-06 0 1.356e-06 0 1.359e-06 0 1.359e-06 0 1.362e-06 0 1.362e-06 0 1.365e-06 0 1.365e-06 0 1.368e-06 0 1.368e-06 0 1.371e-06 0 1.371e-06 0 1.374e-06 0 1.374e-06 0 1.377e-06 0 1.377e-06 0 1.38e-06 0 1.38e-06 0 1.383e-06 0 1.383e-06 0 1.386e-06 0 1.386e-06 0 1.389e-06 0 1.389e-06 0 1.392e-06 0 1.392e-06 0 1.395e-06 0 1.395e-06 0 1.398e-06 0 1.398e-06 0 1.401e-06 0 1.401e-06 0 1.404e-06 0 1.404e-06 0 1.407e-06 0 1.407e-06 0 1.41e-06 0 1.41e-06 0 1.413e-06 0 1.413e-06 0 1.416e-06 0 1.416e-06 0 1.419e-06 0 1.419e-06 0 1.422e-06 0 1.422e-06 0 1.425e-06 0 1.425e-06 0 1.428e-06 0 1.428e-06 0 1.431e-06 0 1.431e-06 0 1.434e-06 0 1.434e-06 0 1.437e-06 0 1.437e-06 0 1.44e-06 0 1.44e-06 0 1.443e-06 0 1.443e-06 0 1.446e-06 0 1.446e-06 0 1.449e-06 0 1.449e-06 0 1.452e-06 0 1.452e-06 0 1.455e-06 0 1.455e-06 0 1.458e-06 0 1.458e-06 0 1.461e-06 0 1.461e-06 0 1.464e-06 0 1.464e-06 0 1.467e-06 0 1.467e-06 0 1.47e-06 0 1.47e-06 0 1.473e-06 0 1.473e-06 0 1.476e-06 0 1.476e-06 0 1.479e-06 0 1.479e-06 0 1.482e-06 0 1.482e-06 0 1.485e-06 0 1.485e-06 0 1.488e-06 0 1.488e-06 0 1.491e-06 0 1.491e-06 0 1.494e-06 0 1.494e-06 0 1.497e-06 0 1.497e-06 0 1.5e-06 0 1.5e-06 0 1.503e-06 0 1.503e-06 0 1.506e-06 0 1.506e-06 0 1.509e-06 0 1.509e-06 0 1.512e-06 0 1.512e-06 0 1.515e-06 0 1.515e-06 0 1.518e-06 0 1.518e-06 0 1.521e-06 0 1.521e-06 0 1.524e-06 0 1.524e-06 0 1.527e-06 0 1.527e-06 0 1.53e-06 0 1.53e-06 0 1.533e-06 0 1.533e-06 0)
VB3 B3 0 PWL(0 0 3e-09 0 3.05e-09 0 6e-09 0 6.05e-09 0 9e-09 0 9.05e-09 0 1.2e-08 0 1.205e-08 0 1.5e-08 0 1.505e-08 0 1.8e-08 0 1.805e-08 0 2.1e-08 0 2.105e-08 0 2.4e-08 0 2.405e-08 0 2.7e-08 0 2.705e-08 0 3e-08 0 3.005e-08 0 3.3e-08 0 3.305e-08 0 3.6e-08 0 3.605e-08 0 3.9e-08 0 3.905e-08 0 4.2e-08 0 4.205e-08 0 4.5e-08 0 4.505e-08 0 4.8e-08 0 4.805e-08 0 5.1e-08 0 5.105e-08 0 5.4e-08 0 5.405e-08 0 5.7e-08 0 5.705e-08 0 6e-08 0 6.005e-08 0 6.3e-08 0 6.305e-08 0 6.6e-08 0 6.605e-08 0 6.9e-08 0 6.905e-08 0 7.2e-08 0 7.205e-08 0 7.5e-08 0 7.505e-08 0 7.8e-08 0 7.805e-08 0 8.1e-08 0 8.105e-08 0 8.4e-08 0 8.405e-08 0 8.7e-08 0 8.705e-08 0 9e-08 0 9.005e-08 0 9.3e-08 0 9.305e-08 0 9.6e-08 0 9.605e-08 0 9.9e-08 0 9.905e-08 0 1.02e-07 0 1.021e-07 0 1.05e-07 0 1.051e-07 0 1.08e-07 0 1.081e-07 0 1.11e-07 0 1.111e-07 0 1.14e-07 0 1.141e-07 0 1.17e-07 0 1.171e-07 0 1.2e-07 0 1.2e-07 0 1.23e-07 0 1.231e-07 0 1.26e-07 0 1.26e-07 0 1.29e-07 0 1.291e-07 0 1.32e-07 0 1.32e-07 0 1.35e-07 0 1.351e-07 0 1.38e-07 0 1.38e-07 0 1.41e-07 0 1.411e-07 0 1.44e-07 0 1.44e-07 0 1.47e-07 0 1.471e-07 0 1.5e-07 0 1.5e-07 0 1.53e-07 0 1.531e-07 0 1.56e-07 0 1.56e-07 0 1.59e-07 0 1.591e-07 0 1.62e-07 0 1.62e-07 0 1.65e-07 0 1.651e-07 0 1.68e-07 0 1.68e-07 0 1.71e-07 0 1.711e-07 0 1.74e-07 0 1.741e-07 0 1.77e-07 0 1.771e-07 0 1.8e-07 0 1.801e-07 0 1.83e-07 0 1.831e-07 0 1.86e-07 0 1.861e-07 0 1.89e-07 0 1.891e-07 0 1.92e-07 0 1.921e-07 0 1.95e-07 0 1.95e-07 0 1.98e-07 0 1.981e-07 0 2.01e-07 0 2.01e-07 0 2.04e-07 0 2.041e-07 0 2.07e-07 0 2.07e-07 0 2.1e-07 0 2.101e-07 0 2.13e-07 0 2.13e-07 0 2.16e-07 0 2.161e-07 0 2.19e-07 0 2.19e-07 0 2.22e-07 0 2.221e-07 0 2.25e-07 0 2.25e-07 0 2.28e-07 0 2.281e-07 0 2.31e-07 0 2.31e-07 0 2.34e-07 0 2.341e-07 0 2.37e-07 0 2.37e-07 0 2.4e-07 0 2.4e-07 0 2.43e-07 0 2.43e-07 0 2.46e-07 0 2.461e-07 0 2.49e-07 0 2.491e-07 0 2.52e-07 0 2.52e-07 0 2.55e-07 0 2.55e-07 0 2.58e-07 0 2.581e-07 0 2.61e-07 0 2.611e-07 0 2.64e-07 0 2.64e-07 0 2.67e-07 0 2.67e-07 0 2.7e-07 0 2.701e-07 0 2.73e-07 0 2.731e-07 0 2.76e-07 0 2.76e-07 0 2.79e-07 0 2.791e-07 0 2.82e-07 0 2.821e-07 0 2.85e-07 0 2.851e-07 0 2.88e-07 0 2.88e-07 0 2.91e-07 0 2.911e-07 0 2.94e-07 0 2.941e-07 0 2.97e-07 0 2.97e-07 0 3e-07 0 3e-07 0 3.03e-07 0 3.031e-07 0 3.06e-07 0 3.061e-07 0 3.09e-07 0 3.09e-07 0 3.12e-07 0 3.12e-07 0 3.15e-07 0 3.151e-07 0 3.18e-07 0 3.181e-07 0 3.21e-07 0 3.21e-07 0 3.24e-07 0 3.24e-07 0 3.27e-07 0 3.271e-07 0 3.3e-07 0 3.301e-07 0 3.33e-07 0 3.33e-07 0 3.36e-07 0 3.36e-07 0 3.39e-07 0 3.391e-07 0 3.42e-07 0 3.421e-07 0 3.45e-07 0 3.45e-07 0 3.48e-07 0 3.48e-07 0 3.51e-07 0 3.511e-07 0 3.54e-07 0 3.541e-07 0 3.57e-07 0 3.57e-07 0 3.6e-07 0 3.6e-07 0 3.63e-07 0 3.631e-07 0 3.66e-07 0 3.661e-07 0 3.69e-07 0 3.69e-07 0 3.72e-07 0 3.72e-07 0 3.75e-07 0 3.751e-07 0 3.78e-07 0 3.781e-07 0 3.81e-07 0 3.81e-07 0 3.84e-07 0 3.841e-07 3.3 3.87e-07 3.3 3.871e-07 3.3 3.9e-07 3.3 3.9e-07 3.3 3.93e-07 3.3 3.93e-07 3.3 3.96e-07 3.3 3.961e-07 3.3 3.99e-07 3.3 3.991e-07 3.3 4.02e-07 3.3 4.02e-07 3.3 4.05e-07 3.3 4.05e-07 3.3 4.08e-07 3.3 4.081e-07 3.3 4.11e-07 3.3 4.111e-07 3.3 4.14e-07 3.3 4.14e-07 3.3 4.17e-07 3.3 4.17e-07 3.3 4.2e-07 3.3 4.201e-07 3.3 4.23e-07 3.3 4.231e-07 3.3 4.26e-07 3.3 4.26e-07 3.3 4.29e-07 3.3 4.29e-07 3.3 4.32e-07 3.3 4.321e-07 3.3 4.35e-07 3.3 4.351e-07 3.3 4.38e-07 3.3 4.38e-07 3.3 4.41e-07 3.3 4.41e-07 3.3 4.44e-07 3.3 4.441e-07 3.3 4.47e-07 3.3 4.471e-07 3.3 4.5e-07 3.3 4.5e-07 3.3 4.53e-07 3.3 4.53e-07 3.3 4.56e-07 3.3 4.561e-07 3.3 4.59e-07 3.3 4.591e-07 3.3 4.62e-07 3.3 4.62e-07 3.3 4.65e-07 3.3 4.65e-07 3.3 4.68e-07 3.3 4.681e-07 3.3 4.71e-07 3.3 4.711e-07 3.3 4.74e-07 3.3 4.74e-07 3.3 4.77e-07 3.3 4.771e-07 3.3 4.8e-07 3.3 4.8e-07 3.3 4.83e-07 3.3 4.83e-07 3.3 4.86e-07 3.3 4.86e-07 3.3 4.89e-07 3.3 4.891e-07 3.3 4.92e-07 3.3 4.921e-07 3.3 4.95e-07 3.3 4.951e-07 3.3 4.98e-07 3.3 4.981e-07 3.3 5.01e-07 3.3 5.01e-07 3.3 5.04e-07 3.3 5.04e-07 3.3 5.07e-07 3.3 5.07e-07 3.3 5.1e-07 3.3 5.1e-07 3.3 5.13e-07 3.3 5.131e-07 3.3 5.16e-07 3.3 5.161e-07 3.3 5.19e-07 3.3 5.191e-07 3.3 5.22e-07 3.3 5.221e-07 3.3 5.25e-07 3.3 5.25e-07 3.3 5.28e-07 3.3 5.28e-07 3.3 5.31e-07 3.3 5.31e-07 3.3 5.34e-07 3.3 5.34e-07 3.3 5.37e-07 3.3 5.371e-07 3.3 5.4e-07 3.3 5.401e-07 3.3 5.43e-07 3.3 5.431e-07 3.3 5.46e-07 3.3 5.461e-07 3.3 5.49e-07 3.3 5.49e-07 3.3 5.52e-07 3.3 5.52e-07 3.3 5.55e-07 3.3 5.55e-07 3.3 5.58e-07 3.3 5.58e-07 3.3 5.61e-07 3.3 5.611e-07 3.3 5.64e-07 3.3 5.641e-07 3.3 5.67e-07 3.3 5.671e-07 3.3 5.7e-07 3.3 5.701e-07 3.3 5.73e-07 3.3 5.73e-07 3.3 5.76e-07 3.3 5.76e-07 3.3 5.79e-07 3.3 5.79e-07 3.3 5.82e-07 3.3 5.821e-07 3.3 5.85e-07 3.3 5.851e-07 3.3 5.88e-07 3.3 5.881e-07 3.3 5.91e-07 3.3 5.911e-07 3.3 5.94e-07 3.3 5.94e-07 3.3 5.97e-07 3.3 5.97e-07 3.3 6e-07 3.3 6e-07 3.3 6.03e-07 3.3 6.03e-07 3.3 6.06e-07 3.3 6.061e-07 3.3 6.09e-07 3.3 6.091e-07 3.3 6.12e-07 3.3 6.121e-07 3.3 6.15e-07 3.3 6.151e-07 3.3 6.18e-07 3.3 6.18e-07 3.3 6.21e-07 3.3 6.21e-07 3.3 6.24e-07 3.3 6.24e-07 3.3 6.27e-07 3.3 6.27e-07 3.3 6.3e-07 3.3 6.301e-07 3.3 6.33e-07 3.3 6.331e-07 3.3 6.36e-07 3.3 6.361e-07 3.3 6.39e-07 3.3 6.391e-07 3.3 6.42e-07 3.3 6.42e-07 3.3 6.45e-07 3.3 6.45e-07 3.3 6.48e-07 3.3 6.48e-07 3.3 6.51e-07 3.3 6.51e-07 3.3 6.54e-07 3.3 6.541e-07 3.3 6.57e-07 3.3 6.571e-07 3.3 6.6e-07 3.3 6.601e-07 3.3 6.63e-07 3.3 6.631e-07 3.3 6.66e-07 3.3 6.66e-07 3.3 6.69e-07 3.3 6.69e-07 3.3 6.72e-07 3.3 6.72e-07 3.3 6.75e-07 3.3 6.75e-07 3.3 6.78e-07 3.3 6.781e-07 3.3 6.81e-07 3.3 6.811e-07 3.3 6.84e-07 3.3 6.841e-07 3.3 6.87e-07 3.3 6.87e-07 3.3 6.9e-07 3.3 6.9e-07 3.3 6.93e-07 3.3 6.93e-07 3.3 6.96e-07 3.3 6.96e-07 3.3 6.99e-07 3.3 6.991e-07 3.3 7.02e-07 3.3 7.021e-07 3.3 7.05e-07 3.3 7.051e-07 3.3 7.08e-07 3.3 7.081e-07 3.3 7.11e-07 3.3 7.11e-07 3.3 7.14e-07 3.3 7.14e-07 3.3 7.17e-07 3.3 7.17e-07 3.3 7.2e-07 3.3 7.2e-07 3.3 7.23e-07 3.3 7.231e-07 3.3 7.26e-07 3.3 7.261e-07 3.3 7.29e-07 3.3 7.291e-07 3.3 7.32e-07 3.3 7.321e-07 3.3 7.35e-07 3.3 7.35e-07 3.3 7.38e-07 3.3 7.38e-07 3.3 7.41e-07 3.3 7.41e-07 3.3 7.44e-07 3.3 7.44e-07 3.3 7.47e-07 3.3 7.471e-07 3.3 7.5e-07 3.3 7.501e-07 3.3 7.53e-07 3.3 7.531e-07 3.3 7.56e-07 3.3 7.561e-07 3.3 7.59e-07 3.3 7.59e-07 3.3 7.62e-07 3.3 7.62e-07 3.3 7.65e-07 3.3 7.65e-07 3.3 7.68e-07 3.3 7.68e-07 3.3 7.71e-07 3.3 7.711e-07 3.3 7.74e-07 3.3 7.741e-07 3.3 7.77e-07 3.3 7.771e-07 3.3 7.8e-07 3.3 7.8e-07 3.3 7.83e-07 3.3 7.83e-07 3.3 7.86e-07 3.3 7.86e-07 3.3 7.89e-07 3.3 7.89e-07 3.3 7.92e-07 3.3 7.921e-07 3.3 7.95e-07 3.3 7.951e-07 3.3 7.98e-07 3.3 7.981e-07 3.3 8.01e-07 3.3 8.011e-07 3.3 8.04e-07 3.3 8.04e-07 3.3 8.07e-07 3.3 8.07e-07 3.3 8.1e-07 3.3 8.1e-07 3.3 8.13e-07 3.3 8.13e-07 3.3 8.16e-07 3.3 8.161e-07 3.3 8.19e-07 3.3 8.191e-07 3.3 8.22e-07 3.3 8.221e-07 3.3 8.25e-07 3.3 8.251e-07 3.3 8.28e-07 3.3 8.28e-07 3.3 8.31e-07 3.3 8.31e-07 3.3 8.34e-07 3.3 8.34e-07 3.3 8.37e-07 3.3 8.37e-07 3.3 8.4e-07 3.3 8.401e-07 3.3 8.43e-07 3.3 8.431e-07 3.3 8.46e-07 3.3 8.461e-07 3.3 8.49e-07 3.3 8.491e-07 3.3 8.52e-07 3.3 8.52e-07 3.3 8.55e-07 3.3 8.55e-07 3.3 8.58e-07 3.3 8.58e-07 3.3 8.61e-07 3.3 8.61e-07 3.3 8.64e-07 3.3 8.641e-07 3.3 8.67e-07 3.3 8.671e-07 3.3 8.7e-07 3.3 8.701e-07 3.3 8.73e-07 3.3 8.73e-07 3.3 8.76e-07 3.3 8.76e-07 3.3 8.79e-07 3.3 8.79e-07 3.3 8.82e-07 3.3 8.82e-07 3.3 8.85e-07 3.3 8.851e-07 3.3 8.88e-07 3.3 8.881e-07 3.3 8.91e-07 3.3 8.911e-07 3.3 8.94e-07 3.3 8.941e-07 3.3 8.97e-07 3.3 8.97e-07 3.3 9e-07 3.3 9e-07 3.3 9.03e-07 3.3 9.03e-07 3.3 9.06e-07 3.3 9.06e-07 3.3 9.09e-07 3.3 9.091e-07 3.3 9.12e-07 3.3 9.121e-07 3.3 9.15e-07 3.3 9.151e-07 3.3 9.18e-07 3.3 9.181e-07 3.3 9.21e-07 3.3 9.21e-07 3.3 9.24e-07 3.3 9.24e-07 3.3 9.27e-07 3.3 9.27e-07 3.3 9.3e-07 3.3 9.3e-07 3.3 9.33e-07 3.3 9.331e-07 3.3 9.36e-07 3.3 9.361e-07 3.3 9.39e-07 3.3 9.391e-07 3.3 9.42e-07 3.3 9.421e-07 3.3 9.45e-07 3.3 9.45e-07 3.3 9.48e-07 3.3 9.48e-07 3.3 9.51e-07 3.3 9.51e-07 3.3 9.54e-07 3.3 9.54e-07 3.3 9.57e-07 3.3 9.57e-07 3.3 9.6e-07 3.3 9.6e-07 3.3 9.63e-07 3.3 9.63e-07 3.3 9.66e-07 3.3 9.66e-07 3.3 9.69e-07 3.3 9.69e-07 3.3 9.72e-07 3.3 9.72e-07 3.3 9.75e-07 3.3 9.75e-07 3.3 9.78e-07 3.3 9.78e-07 3.3 9.81e-07 3.3 9.81e-07 3.3 9.84e-07 3.3 9.84e-07 3.3 9.87e-07 3.3 9.87e-07 3.3 9.9e-07 3.3 9.9e-07 3.3 9.93e-07 3.3 9.93e-07 3.3 9.96e-07 3.3 9.96e-07 3.3 9.99e-07 3.3 9.99e-07 3.3 1.002e-06 3.3 1.002e-06 3.3 1.005e-06 3.3 1.005e-06 3.3 1.008e-06 3.3 1.008e-06 3.3 1.011e-06 3.3 1.011e-06 3.3 1.014e-06 3.3 1.014e-06 3.3 1.017e-06 3.3 1.017e-06 3.3 1.02e-06 3.3 1.02e-06 3.3 1.023e-06 3.3 1.023e-06 3.3 1.026e-06 3.3 1.026e-06 3.3 1.029e-06 3.3 1.029e-06 3.3 1.032e-06 3.3 1.032e-06 3.3 1.035e-06 3.3 1.035e-06 3.3 1.038e-06 3.3 1.038e-06 3.3 1.041e-06 3.3 1.041e-06 3.3 1.044e-06 3.3 1.044e-06 3.3 1.047e-06 3.3 1.047e-06 3.3 1.05e-06 3.3 1.05e-06 3.3 1.053e-06 3.3 1.053e-06 3.3 1.056e-06 3.3 1.056e-06 3.3 1.059e-06 3.3 1.059e-06 3.3 1.062e-06 3.3 1.062e-06 3.3 1.065e-06 3.3 1.065e-06 3.3 1.068e-06 3.3 1.068e-06 3.3 1.071e-06 3.3 1.071e-06 3.3 1.074e-06 3.3 1.074e-06 3.3 1.077e-06 3.3 1.077e-06 3.3 1.08e-06 3.3 1.08e-06 3.3 1.083e-06 3.3 1.083e-06 3.3 1.086e-06 3.3 1.086e-06 3.3 1.089e-06 3.3 1.089e-06 3.3 1.092e-06 3.3 1.092e-06 3.3 1.095e-06 3.3 1.095e-06 3.3 1.098e-06 3.3 1.098e-06 3.3 1.101e-06 3.3 1.101e-06 3.3 1.104e-06 3.3 1.104e-06 3.3 1.107e-06 3.3 1.107e-06 3.3 1.11e-06 3.3 1.11e-06 3.3 1.113e-06 3.3 1.113e-06 3.3 1.116e-06 3.3 1.116e-06 3.3 1.119e-06 3.3 1.119e-06 3.3 1.122e-06 3.3 1.122e-06 3.3 1.125e-06 3.3 1.125e-06 3.3 1.128e-06 3.3 1.128e-06 3.3 1.131e-06 3.3 1.131e-06 3.3 1.134e-06 3.3 1.134e-06 3.3 1.137e-06 3.3 1.137e-06 3.3 1.14e-06 3.3 1.14e-06 3.3 1.143e-06 3.3 1.143e-06 3.3 1.146e-06 3.3 1.146e-06 3.3 1.149e-06 3.3 1.149e-06 3.3 1.152e-06 3.3 1.152e-06 0 1.155e-06 0 1.155e-06 0 1.158e-06 0 1.158e-06 0 1.161e-06 0 1.161e-06 0 1.164e-06 0 1.164e-06 0 1.167e-06 0 1.167e-06 0 1.17e-06 0 1.17e-06 0 1.173e-06 0 1.173e-06 0 1.176e-06 0 1.176e-06 0 1.179e-06 0 1.179e-06 0 1.182e-06 0 1.182e-06 0 1.185e-06 0 1.185e-06 0 1.188e-06 0 1.188e-06 0 1.191e-06 0 1.191e-06 0 1.194e-06 0 1.194e-06 0 1.197e-06 0 1.197e-06 0 1.2e-06 0 1.2e-06 0 1.203e-06 0 1.203e-06 0 1.206e-06 0 1.206e-06 0 1.209e-06 0 1.209e-06 0 1.212e-06 0 1.212e-06 0 1.215e-06 0 1.215e-06 0 1.218e-06 0 1.218e-06 0 1.221e-06 0 1.221e-06 0 1.224e-06 0 1.224e-06 0 1.227e-06 0 1.227e-06 0 1.23e-06 0 1.23e-06 0 1.233e-06 0 1.233e-06 0 1.236e-06 0 1.236e-06 0 1.239e-06 0 1.239e-06 0 1.242e-06 0 1.242e-06 0 1.245e-06 0 1.245e-06 0 1.248e-06 0 1.248e-06 0 1.251e-06 0 1.251e-06 0 1.254e-06 0 1.254e-06 0 1.257e-06 0 1.257e-06 0 1.26e-06 0 1.26e-06 0 1.263e-06 0 1.263e-06 0 1.266e-06 0 1.266e-06 0 1.269e-06 0 1.269e-06 0 1.272e-06 0 1.272e-06 0 1.275e-06 0 1.275e-06 0 1.278e-06 0 1.278e-06 0 1.281e-06 0 1.281e-06 0 1.284e-06 0 1.284e-06 0 1.287e-06 0 1.287e-06 0 1.29e-06 0 1.29e-06 0 1.293e-06 0 1.293e-06 0 1.296e-06 0 1.296e-06 0 1.299e-06 0 1.299e-06 0 1.302e-06 0 1.302e-06 0 1.305e-06 0 1.305e-06 0 1.308e-06 0 1.308e-06 0 1.311e-06 0 1.311e-06 0 1.314e-06 0 1.314e-06 0 1.317e-06 0 1.317e-06 0 1.32e-06 0 1.32e-06 0 1.323e-06 0 1.323e-06 0 1.326e-06 0 1.326e-06 0 1.329e-06 0 1.329e-06 0 1.332e-06 0 1.332e-06 0 1.335e-06 0 1.335e-06 0 1.338e-06 0 1.338e-06 0 1.341e-06 0 1.341e-06 0 1.344e-06 0 1.344e-06 0 1.347e-06 0 1.347e-06 0 1.35e-06 0 1.35e-06 0 1.353e-06 0 1.353e-06 0 1.356e-06 0 1.356e-06 0 1.359e-06 0 1.359e-06 0 1.362e-06 0 1.362e-06 0 1.365e-06 0 1.365e-06 0 1.368e-06 0 1.368e-06 0 1.371e-06 0 1.371e-06 0 1.374e-06 0 1.374e-06 0 1.377e-06 0 1.377e-06 0 1.38e-06 0 1.38e-06 0 1.383e-06 0 1.383e-06 0 1.386e-06 0 1.386e-06 0 1.389e-06 0 1.389e-06 0 1.392e-06 0 1.392e-06 0 1.395e-06 0 1.395e-06 0 1.398e-06 0 1.398e-06 0 1.401e-06 0 1.401e-06 0 1.404e-06 0 1.404e-06 0 1.407e-06 0 1.407e-06 0 1.41e-06 0 1.41e-06 0 1.413e-06 0 1.413e-06 0 1.416e-06 0 1.416e-06 0 1.419e-06 0 1.419e-06 0 1.422e-06 0 1.422e-06 0 1.425e-06 0 1.425e-06 0 1.428e-06 0 1.428e-06 0 1.431e-06 0 1.431e-06 0 1.434e-06 0 1.434e-06 0 1.437e-06 0 1.437e-06 0 1.44e-06 0 1.44e-06 0 1.443e-06 0 1.443e-06 0 1.446e-06 0 1.446e-06 0 1.449e-06 0 1.449e-06 0 1.452e-06 0 1.452e-06 0 1.455e-06 0 1.455e-06 0 1.458e-06 0 1.458e-06 0 1.461e-06 0 1.461e-06 0 1.464e-06 0 1.464e-06 0 1.467e-06 0 1.467e-06 0 1.47e-06 0 1.47e-06 0 1.473e-06 0 1.473e-06 0 1.476e-06 0 1.476e-06 0 1.479e-06 0 1.479e-06 0 1.482e-06 0 1.482e-06 0 1.485e-06 0 1.485e-06 0 1.488e-06 0 1.488e-06 0 1.491e-06 0 1.491e-06 0 1.494e-06 0 1.494e-06 0 1.497e-06 0 1.497e-06 0 1.5e-06 0 1.5e-06 0 1.503e-06 0 1.503e-06 0 1.506e-06 0 1.506e-06 0 1.509e-06 0 1.509e-06 0 1.512e-06 0 1.512e-06 0 1.515e-06 0 1.515e-06 0 1.518e-06 0 1.518e-06 0 1.521e-06 0 1.521e-06 0 1.524e-06 0 1.524e-06 0 1.527e-06 0 1.527e-06 0 1.53e-06 0 1.53e-06 0 1.533e-06 0 1.533e-06 0)
VCin Cin 0 PWL(0 0 3e-09 0 3.05e-09 0 6e-09 0 6.05e-09 0 9e-09 0 9.05e-09 0 1.2e-08 0 1.205e-08 0 1.5e-08 0 1.505e-08 0 1.8e-08 0 1.805e-08 0 2.1e-08 0 2.105e-08 0 2.4e-08 0 2.405e-08 0 2.7e-08 0 2.705e-08 0 3e-08 0 3.005e-08 0 3.3e-08 0 3.305e-08 0 3.6e-08 0 3.605e-08 0 3.9e-08 0 3.905e-08 0 4.2e-08 0 4.205e-08 0 4.5e-08 0 4.505e-08 0 4.8e-08 0 4.805e-08 0 5.1e-08 0 5.105e-08 0 5.4e-08 0 5.405e-08 0 5.7e-08 0 5.705e-08 0 6e-08 0 6.005e-08 0 6.3e-08 0 6.305e-08 0 6.6e-08 0 6.605e-08 0 6.9e-08 0 6.905e-08 0 7.2e-08 0 7.205e-08 0 7.5e-08 0 7.505e-08 0 7.8e-08 0 7.805e-08 0 8.1e-08 0 8.105e-08 0 8.4e-08 0 8.405e-08 0 8.7e-08 0 8.705e-08 0 9e-08 0 9.005e-08 0 9.3e-08 0 9.305e-08 0 9.6e-08 0 9.605e-08 0 9.9e-08 0 9.905e-08 0 1.02e-07 0 1.021e-07 0 1.05e-07 0 1.051e-07 0 1.08e-07 0 1.081e-07 0 1.11e-07 0 1.111e-07 0 1.14e-07 0 1.141e-07 0 1.17e-07 0 1.171e-07 0 1.2e-07 0 1.2e-07 0 1.23e-07 0 1.231e-07 0 1.26e-07 0 1.26e-07 0 1.29e-07 0 1.291e-07 0 1.32e-07 0 1.32e-07 0 1.35e-07 0 1.351e-07 0 1.38e-07 0 1.38e-07 0 1.41e-07 0 1.411e-07 0 1.44e-07 0 1.44e-07 0 1.47e-07 0 1.471e-07 0 1.5e-07 0 1.5e-07 0 1.53e-07 0 1.531e-07 0 1.56e-07 0 1.56e-07 0 1.59e-07 0 1.591e-07 0 1.62e-07 0 1.62e-07 0 1.65e-07 0 1.651e-07 0 1.68e-07 0 1.68e-07 0 1.71e-07 0 1.711e-07 0 1.74e-07 0 1.741e-07 0 1.77e-07 0 1.771e-07 0 1.8e-07 0 1.801e-07 0 1.83e-07 0 1.831e-07 0 1.86e-07 0 1.861e-07 0 1.89e-07 0 1.891e-07 0 1.92e-07 0 1.921e-07 0 1.95e-07 0 1.95e-07 0 1.98e-07 0 1.981e-07 0 2.01e-07 0 2.01e-07 0 2.04e-07 0 2.041e-07 0 2.07e-07 0 2.07e-07 0 2.1e-07 0 2.101e-07 0 2.13e-07 0 2.13e-07 0 2.16e-07 0 2.161e-07 0 2.19e-07 0 2.19e-07 0 2.22e-07 0 2.221e-07 0 2.25e-07 0 2.25e-07 0 2.28e-07 0 2.281e-07 0 2.31e-07 0 2.31e-07 0 2.34e-07 0 2.341e-07 0 2.37e-07 0 2.37e-07 0 2.4e-07 0 2.4e-07 0 2.43e-07 0 2.43e-07 0 2.46e-07 0 2.461e-07 0 2.49e-07 0 2.491e-07 0 2.52e-07 0 2.52e-07 0 2.55e-07 0 2.55e-07 0 2.58e-07 0 2.581e-07 0 2.61e-07 0 2.611e-07 0 2.64e-07 0 2.64e-07 0 2.67e-07 0 2.67e-07 0 2.7e-07 0 2.701e-07 0 2.73e-07 0 2.731e-07 0 2.76e-07 0 2.76e-07 0 2.79e-07 0 2.791e-07 0 2.82e-07 0 2.821e-07 0 2.85e-07 0 2.851e-07 0 2.88e-07 0 2.88e-07 0 2.91e-07 0 2.911e-07 0 2.94e-07 0 2.941e-07 0 2.97e-07 0 2.97e-07 0 3e-07 0 3e-07 0 3.03e-07 0 3.031e-07 0 3.06e-07 0 3.061e-07 0 3.09e-07 0 3.09e-07 0 3.12e-07 0 3.12e-07 0 3.15e-07 0 3.151e-07 0 3.18e-07 0 3.181e-07 0 3.21e-07 0 3.21e-07 0 3.24e-07 0 3.24e-07 0 3.27e-07 0 3.271e-07 0 3.3e-07 0 3.301e-07 0 3.33e-07 0 3.33e-07 0 3.36e-07 0 3.36e-07 0 3.39e-07 0 3.391e-07 0 3.42e-07 0 3.421e-07 0 3.45e-07 0 3.45e-07 0 3.48e-07 0 3.48e-07 0 3.51e-07 0 3.511e-07 0 3.54e-07 0 3.541e-07 0 3.57e-07 0 3.57e-07 0 3.6e-07 0 3.6e-07 0 3.63e-07 0 3.631e-07 0 3.66e-07 0 3.661e-07 0 3.69e-07 0 3.69e-07 0 3.72e-07 0 3.72e-07 0 3.75e-07 0 3.751e-07 0 3.78e-07 0 3.781e-07 0 3.81e-07 0 3.81e-07 0 3.84e-07 0 3.841e-07 0 3.87e-07 0 3.871e-07 0 3.9e-07 0 3.9e-07 0 3.93e-07 0 3.93e-07 0 3.96e-07 0 3.961e-07 0 3.99e-07 0 3.991e-07 0 4.02e-07 0 4.02e-07 0 4.05e-07 0 4.05e-07 0 4.08e-07 0 4.081e-07 0 4.11e-07 0 4.111e-07 0 4.14e-07 0 4.14e-07 0 4.17e-07 0 4.17e-07 0 4.2e-07 0 4.201e-07 0 4.23e-07 0 4.231e-07 0 4.26e-07 0 4.26e-07 0 4.29e-07 0 4.29e-07 0 4.32e-07 0 4.321e-07 0 4.35e-07 0 4.351e-07 0 4.38e-07 0 4.38e-07 0 4.41e-07 0 4.41e-07 0 4.44e-07 0 4.441e-07 0 4.47e-07 0 4.471e-07 0 4.5e-07 0 4.5e-07 0 4.53e-07 0 4.53e-07 0 4.56e-07 0 4.561e-07 0 4.59e-07 0 4.591e-07 0 4.62e-07 0 4.62e-07 0 4.65e-07 0 4.65e-07 0 4.68e-07 0 4.681e-07 0 4.71e-07 0 4.711e-07 0 4.74e-07 0 4.74e-07 0 4.77e-07 0 4.771e-07 0 4.8e-07 0 4.8e-07 0 4.83e-07 0 4.83e-07 0 4.86e-07 0 4.86e-07 0 4.89e-07 0 4.891e-07 0 4.92e-07 0 4.921e-07 0 4.95e-07 0 4.951e-07 0 4.98e-07 0 4.981e-07 0 5.01e-07 0 5.01e-07 0 5.04e-07 0 5.04e-07 0 5.07e-07 0 5.07e-07 0 5.1e-07 0 5.1e-07 0 5.13e-07 0 5.131e-07 0 5.16e-07 0 5.161e-07 0 5.19e-07 0 5.191e-07 0 5.22e-07 0 5.221e-07 0 5.25e-07 0 5.25e-07 0 5.28e-07 0 5.28e-07 0 5.31e-07 0 5.31e-07 0 5.34e-07 0 5.34e-07 0 5.37e-07 0 5.371e-07 0 5.4e-07 0 5.401e-07 0 5.43e-07 0 5.431e-07 0 5.46e-07 0 5.461e-07 0 5.49e-07 0 5.49e-07 0 5.52e-07 0 5.52e-07 0 5.55e-07 0 5.55e-07 0 5.58e-07 0 5.58e-07 0 5.61e-07 0 5.611e-07 0 5.64e-07 0 5.641e-07 0 5.67e-07 0 5.671e-07 0 5.7e-07 0 5.701e-07 0 5.73e-07 0 5.73e-07 0 5.76e-07 0 5.76e-07 0 5.79e-07 0 5.79e-07 0 5.82e-07 0 5.821e-07 0 5.85e-07 0 5.851e-07 0 5.88e-07 0 5.881e-07 0 5.91e-07 0 5.911e-07 0 5.94e-07 0 5.94e-07 0 5.97e-07 0 5.97e-07 0 6e-07 0 6e-07 0 6.03e-07 0 6.03e-07 0 6.06e-07 0 6.061e-07 0 6.09e-07 0 6.091e-07 0 6.12e-07 0 6.121e-07 0 6.15e-07 0 6.151e-07 0 6.18e-07 0 6.18e-07 0 6.21e-07 0 6.21e-07 0 6.24e-07 0 6.24e-07 0 6.27e-07 0 6.27e-07 0 6.3e-07 0 6.301e-07 0 6.33e-07 0 6.331e-07 0 6.36e-07 0 6.361e-07 0 6.39e-07 0 6.391e-07 0 6.42e-07 0 6.42e-07 0 6.45e-07 0 6.45e-07 0 6.48e-07 0 6.48e-07 0 6.51e-07 0 6.51e-07 0 6.54e-07 0 6.541e-07 0 6.57e-07 0 6.571e-07 0 6.6e-07 0 6.601e-07 0 6.63e-07 0 6.631e-07 0 6.66e-07 0 6.66e-07 0 6.69e-07 0 6.69e-07 0 6.72e-07 0 6.72e-07 0 6.75e-07 0 6.75e-07 0 6.78e-07 0 6.781e-07 0 6.81e-07 0 6.811e-07 0 6.84e-07 0 6.841e-07 0 6.87e-07 0 6.87e-07 0 6.9e-07 0 6.9e-07 0 6.93e-07 0 6.93e-07 0 6.96e-07 0 6.96e-07 0 6.99e-07 0 6.991e-07 0 7.02e-07 0 7.021e-07 0 7.05e-07 0 7.051e-07 0 7.08e-07 0 7.081e-07 0 7.11e-07 0 7.11e-07 0 7.14e-07 0 7.14e-07 0 7.17e-07 0 7.17e-07 0 7.2e-07 0 7.2e-07 0 7.23e-07 0 7.231e-07 0 7.26e-07 0 7.261e-07 0 7.29e-07 0 7.291e-07 0 7.32e-07 0 7.321e-07 0 7.35e-07 0 7.35e-07 0 7.38e-07 0 7.38e-07 0 7.41e-07 0 7.41e-07 0 7.44e-07 0 7.44e-07 0 7.47e-07 0 7.471e-07 0 7.5e-07 0 7.501e-07 0 7.53e-07 0 7.531e-07 0 7.56e-07 0 7.561e-07 0 7.59e-07 0 7.59e-07 0 7.62e-07 0 7.62e-07 0 7.65e-07 0 7.65e-07 0 7.68e-07 0 7.68e-07 3.3 7.71e-07 3.3 7.711e-07 3.3 7.74e-07 3.3 7.741e-07 3.3 7.77e-07 3.3 7.771e-07 3.3 7.8e-07 3.3 7.8e-07 3.3 7.83e-07 3.3 7.83e-07 3.3 7.86e-07 3.3 7.86e-07 3.3 7.89e-07 3.3 7.89e-07 3.3 7.92e-07 3.3 7.921e-07 3.3 7.95e-07 3.3 7.951e-07 3.3 7.98e-07 3.3 7.981e-07 3.3 8.01e-07 3.3 8.011e-07 3.3 8.04e-07 3.3 8.04e-07 3.3 8.07e-07 3.3 8.07e-07 3.3 8.1e-07 3.3 8.1e-07 3.3 8.13e-07 3.3 8.13e-07 3.3 8.16e-07 3.3 8.161e-07 3.3 8.19e-07 3.3 8.191e-07 3.3 8.22e-07 3.3 8.221e-07 3.3 8.25e-07 3.3 8.251e-07 3.3 8.28e-07 3.3 8.28e-07 3.3 8.31e-07 3.3 8.31e-07 3.3 8.34e-07 3.3 8.34e-07 3.3 8.37e-07 3.3 8.37e-07 3.3 8.4e-07 3.3 8.401e-07 3.3 8.43e-07 3.3 8.431e-07 3.3 8.46e-07 3.3 8.461e-07 3.3 8.49e-07 3.3 8.491e-07 3.3 8.52e-07 3.3 8.52e-07 3.3 8.55e-07 3.3 8.55e-07 3.3 8.58e-07 3.3 8.58e-07 3.3 8.61e-07 3.3 8.61e-07 3.3 8.64e-07 3.3 8.641e-07 3.3 8.67e-07 3.3 8.671e-07 3.3 8.7e-07 3.3 8.701e-07 3.3 8.73e-07 3.3 8.73e-07 3.3 8.76e-07 3.3 8.76e-07 3.3 8.79e-07 3.3 8.79e-07 3.3 8.82e-07 3.3 8.82e-07 3.3 8.85e-07 3.3 8.851e-07 3.3 8.88e-07 3.3 8.881e-07 3.3 8.91e-07 3.3 8.911e-07 3.3 8.94e-07 3.3 8.941e-07 3.3 8.97e-07 3.3 8.97e-07 3.3 9e-07 3.3 9e-07 3.3 9.03e-07 3.3 9.03e-07 3.3 9.06e-07 3.3 9.06e-07 3.3 9.09e-07 3.3 9.091e-07 3.3 9.12e-07 3.3 9.121e-07 3.3 9.15e-07 3.3 9.151e-07 3.3 9.18e-07 3.3 9.181e-07 3.3 9.21e-07 3.3 9.21e-07 3.3 9.24e-07 3.3 9.24e-07 3.3 9.27e-07 3.3 9.27e-07 3.3 9.3e-07 3.3 9.3e-07 3.3 9.33e-07 3.3 9.331e-07 3.3 9.36e-07 3.3 9.361e-07 3.3 9.39e-07 3.3 9.391e-07 3.3 9.42e-07 3.3 9.421e-07 3.3 9.45e-07 3.3 9.45e-07 3.3 9.48e-07 3.3 9.48e-07 3.3 9.51e-07 3.3 9.51e-07 3.3 9.54e-07 3.3 9.54e-07 3.3 9.57e-07 3.3 9.57e-07 3.3 9.6e-07 3.3 9.6e-07 3.3 9.63e-07 3.3 9.63e-07 3.3 9.66e-07 3.3 9.66e-07 3.3 9.69e-07 3.3 9.69e-07 3.3 9.72e-07 3.3 9.72e-07 3.3 9.75e-07 3.3 9.75e-07 3.3 9.78e-07 3.3 9.78e-07 3.3 9.81e-07 3.3 9.81e-07 3.3 9.84e-07 3.3 9.84e-07 3.3 9.87e-07 3.3 9.87e-07 3.3 9.9e-07 3.3 9.9e-07 3.3 9.93e-07 3.3 9.93e-07 3.3 9.96e-07 3.3 9.96e-07 3.3 9.99e-07 3.3 9.99e-07 3.3 1.002e-06 3.3 1.002e-06 3.3 1.005e-06 3.3 1.005e-06 3.3 1.008e-06 3.3 1.008e-06 3.3 1.011e-06 3.3 1.011e-06 3.3 1.014e-06 3.3 1.014e-06 3.3 1.017e-06 3.3 1.017e-06 3.3 1.02e-06 3.3 1.02e-06 3.3 1.023e-06 3.3 1.023e-06 3.3 1.026e-06 3.3 1.026e-06 3.3 1.029e-06 3.3 1.029e-06 3.3 1.032e-06 3.3 1.032e-06 3.3 1.035e-06 3.3 1.035e-06 3.3 1.038e-06 3.3 1.038e-06 3.3 1.041e-06 3.3 1.041e-06 3.3 1.044e-06 3.3 1.044e-06 3.3 1.047e-06 3.3 1.047e-06 3.3 1.05e-06 3.3 1.05e-06 3.3 1.053e-06 3.3 1.053e-06 3.3 1.056e-06 3.3 1.056e-06 3.3 1.059e-06 3.3 1.059e-06 3.3 1.062e-06 3.3 1.062e-06 3.3 1.065e-06 3.3 1.065e-06 3.3 1.068e-06 3.3 1.068e-06 3.3 1.071e-06 3.3 1.071e-06 3.3 1.074e-06 3.3 1.074e-06 3.3 1.077e-06 3.3 1.077e-06 3.3 1.08e-06 3.3 1.08e-06 3.3 1.083e-06 3.3 1.083e-06 3.3 1.086e-06 3.3 1.086e-06 3.3 1.089e-06 3.3 1.089e-06 3.3 1.092e-06 3.3 1.092e-06 3.3 1.095e-06 3.3 1.095e-06 3.3 1.098e-06 3.3 1.098e-06 3.3 1.101e-06 3.3 1.101e-06 3.3 1.104e-06 3.3 1.104e-06 3.3 1.107e-06 3.3 1.107e-06 3.3 1.11e-06 3.3 1.11e-06 3.3 1.113e-06 3.3 1.113e-06 3.3 1.116e-06 3.3 1.116e-06 3.3 1.119e-06 3.3 1.119e-06 3.3 1.122e-06 3.3 1.122e-06 3.3 1.125e-06 3.3 1.125e-06 3.3 1.128e-06 3.3 1.128e-06 3.3 1.131e-06 3.3 1.131e-06 3.3 1.134e-06 3.3 1.134e-06 3.3 1.137e-06 3.3 1.137e-06 3.3 1.14e-06 3.3 1.14e-06 3.3 1.143e-06 3.3 1.143e-06 3.3 1.146e-06 3.3 1.146e-06 3.3 1.149e-06 3.3 1.149e-06 3.3 1.152e-06 3.3 1.152e-06 3.3 1.155e-06 3.3 1.155e-06 3.3 1.158e-06 3.3 1.158e-06 3.3 1.161e-06 3.3 1.161e-06 3.3 1.164e-06 3.3 1.164e-06 3.3 1.167e-06 3.3 1.167e-06 3.3 1.17e-06 3.3 1.17e-06 3.3 1.173e-06 3.3 1.173e-06 3.3 1.176e-06 3.3 1.176e-06 3.3 1.179e-06 3.3 1.179e-06 3.3 1.182e-06 3.3 1.182e-06 3.3 1.185e-06 3.3 1.185e-06 3.3 1.188e-06 3.3 1.188e-06 3.3 1.191e-06 3.3 1.191e-06 3.3 1.194e-06 3.3 1.194e-06 3.3 1.197e-06 3.3 1.197e-06 3.3 1.2e-06 3.3 1.2e-06 3.3 1.203e-06 3.3 1.203e-06 3.3 1.206e-06 3.3 1.206e-06 3.3 1.209e-06 3.3 1.209e-06 3.3 1.212e-06 3.3 1.212e-06 3.3 1.215e-06 3.3 1.215e-06 3.3 1.218e-06 3.3 1.218e-06 3.3 1.221e-06 3.3 1.221e-06 3.3 1.224e-06 3.3 1.224e-06 3.3 1.227e-06 3.3 1.227e-06 3.3 1.23e-06 3.3 1.23e-06 3.3 1.233e-06 3.3 1.233e-06 3.3 1.236e-06 3.3 1.236e-06 3.3 1.239e-06 3.3 1.239e-06 3.3 1.242e-06 3.3 1.242e-06 3.3 1.245e-06 3.3 1.245e-06 3.3 1.248e-06 3.3 1.248e-06 3.3 1.251e-06 3.3 1.251e-06 3.3 1.254e-06 3.3 1.254e-06 3.3 1.257e-06 3.3 1.257e-06 3.3 1.26e-06 3.3 1.26e-06 3.3 1.263e-06 3.3 1.263e-06 3.3 1.266e-06 3.3 1.266e-06 3.3 1.269e-06 3.3 1.269e-06 3.3 1.272e-06 3.3 1.272e-06 3.3 1.275e-06 3.3 1.275e-06 3.3 1.278e-06 3.3 1.278e-06 3.3 1.281e-06 3.3 1.281e-06 3.3 1.284e-06 3.3 1.284e-06 3.3 1.287e-06 3.3 1.287e-06 3.3 1.29e-06 3.3 1.29e-06 3.3 1.293e-06 3.3 1.293e-06 3.3 1.296e-06 3.3 1.296e-06 3.3 1.299e-06 3.3 1.299e-06 3.3 1.302e-06 3.3 1.302e-06 3.3 1.305e-06 3.3 1.305e-06 3.3 1.308e-06 3.3 1.308e-06 3.3 1.311e-06 3.3 1.311e-06 3.3 1.314e-06 3.3 1.314e-06 3.3 1.317e-06 3.3 1.317e-06 3.3 1.32e-06 3.3 1.32e-06 3.3 1.323e-06 3.3 1.323e-06 3.3 1.326e-06 3.3 1.326e-06 3.3 1.329e-06 3.3 1.329e-06 3.3 1.332e-06 3.3 1.332e-06 3.3 1.335e-06 3.3 1.335e-06 3.3 1.338e-06 3.3 1.338e-06 3.3 1.341e-06 3.3 1.341e-06 3.3 1.344e-06 3.3 1.344e-06 3.3 1.347e-06 3.3 1.347e-06 3.3 1.35e-06 3.3 1.35e-06 3.3 1.353e-06 3.3 1.353e-06 3.3 1.356e-06 3.3 1.356e-06 3.3 1.359e-06 3.3 1.359e-06 3.3 1.362e-06 3.3 1.362e-06 3.3 1.365e-06 3.3 1.365e-06 3.3 1.368e-06 3.3 1.368e-06 3.3 1.371e-06 3.3 1.371e-06 3.3 1.374e-06 3.3 1.374e-06 3.3 1.377e-06 3.3 1.377e-06 3.3 1.38e-06 3.3 1.38e-06 3.3 1.383e-06 3.3 1.383e-06 3.3 1.386e-06 3.3 1.386e-06 3.3 1.389e-06 3.3 1.389e-06 3.3 1.392e-06 3.3 1.392e-06 3.3 1.395e-06 3.3 1.395e-06 3.3 1.398e-06 3.3 1.398e-06 3.3 1.401e-06 3.3 1.401e-06 3.3 1.404e-06 3.3 1.404e-06 3.3 1.407e-06 3.3 1.407e-06 3.3 1.41e-06 3.3 1.41e-06 3.3 1.413e-06 3.3 1.413e-06 3.3 1.416e-06 3.3 1.416e-06 3.3 1.419e-06 3.3 1.419e-06 3.3 1.422e-06 3.3 1.422e-06 3.3 1.425e-06 3.3 1.425e-06 3.3 1.428e-06 3.3 1.428e-06 3.3 1.431e-06 3.3 1.431e-06 3.3 1.434e-06 3.3 1.434e-06 3.3 1.437e-06 3.3 1.437e-06 3.3 1.44e-06 3.3 1.44e-06 3.3 1.443e-06 3.3 1.443e-06 3.3 1.446e-06 3.3 1.446e-06 3.3 1.449e-06 3.3 1.449e-06 3.3 1.452e-06 3.3 1.452e-06 3.3 1.455e-06 3.3 1.455e-06 3.3 1.458e-06 3.3 1.458e-06 3.3 1.461e-06 3.3 1.461e-06 3.3 1.464e-06 3.3 1.464e-06 3.3 1.467e-06 3.3 1.467e-06 3.3 1.47e-06 3.3 1.47e-06 3.3 1.473e-06 3.3 1.473e-06 3.3 1.476e-06 3.3 1.476e-06 3.3 1.479e-06 3.3 1.479e-06 3.3 1.482e-06 3.3 1.482e-06 3.3 1.485e-06 3.3 1.485e-06 3.3 1.488e-06 3.3 1.488e-06 3.3 1.491e-06 3.3 1.491e-06 3.3 1.494e-06 3.3 1.494e-06 3.3 1.497e-06 3.3 1.497e-06 3.3 1.5e-06 3.3 1.5e-06 3.3 1.503e-06 3.3 1.503e-06 3.3 1.506e-06 3.3 1.506e-06 3.3 1.509e-06 3.3 1.509e-06 3.3 1.512e-06 3.3 1.512e-06 3.3 1.515e-06 3.3 1.515e-06 3.3 1.518e-06 3.3 1.518e-06 3.3 1.521e-06 3.3 1.521e-06 3.3 1.524e-06 3.3 1.524e-06 3.3 1.527e-06 3.3 1.527e-06 3.3 1.53e-06 3.3 1.53e-06 3.3 1.533e-06 3.3 1.533e-06 3.3)
CS0 S0 0 1e-14
CS1 S1 0 1e-14
CS2 S2 0 1e-14
CS3 S3 0 1e-14
CCout Cout 0 1e-14
.option method=gear
.control
tran 5p 1.536e-06
wrdata /home/ellis/EG-LOGIC/examples/adder4/gf180mcuD/ADD4_sim.dat v(S0) v(S1) v(S2) v(S3) v(Cout)
quit
.endc
.end
