* OR reference (gf180mcuD)
.subckt OR A B Y VDD VSS
X1 x A p0_1 VDD pfet_03v3 w=2u l=0.28u
X2 p0_1 B VDD VDD pfet_03v3 w=2u l=0.28u
X3 x A VSS VSS nfet_03v3 w=1u l=0.28u
X4 VSS B x VSS nfet_03v3 w=1u l=0.28u
X5 VDD x Y VDD pfet_03v3 w=2u l=0.28u
X6 VSS x Y VSS nfet_03v3 w=1u l=0.28u
.ends
