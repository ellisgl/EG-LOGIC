* NGSPICE file created from NOT.ext - technology: gf180mcuD

.subckt NOT A Y VDD VSS
X0 Y A VDD VDD pfet_03v3 ad=0.9p pd=4.9u as=0.9p ps=4.9u w=2u l=0.28u
X1 Y A VSS VSS nfet_03v3 ad=0.45p pd=2.9u as=0.45p ps=2.9u w=1u l=0.28u
C0 VDD A 0.28836f
C1 VDD Y 0.93857f
C2 A Y 0.05104f
C3 Y VSS 1.82953f
C4 A VSS 0.612f
C5 VDD VSS 4.93225f
.ends
