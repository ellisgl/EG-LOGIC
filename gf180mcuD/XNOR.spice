* NGSPICE file created from XNOR.ext - technology: gf180mcuD

.subckt XNOR A B Y VDD VSS
X0 Y a_1009_n395# VDD VDD pfet_03v3 ad=1.25p pd=5.25u as=0.705p ps=2.705u w=2u l=0.28u
X1 VDD B a_1609_195# VDD pfet_03v3 ad=0.705p pd=2.705u as=0.53p ps=2.53u w=2u l=0.28u
X2 a_1609_195# A Y VDD pfet_03v3 ad=0.53p pd=2.53u as=0.9p ps=4.9u w=2u l=0.28u
X3 VSS B a_1155_n395# VSS nfet_03v3 ad=0.45p pd=2.9u as=0.265p ps=1.53u w=1u l=0.28u
X4 VSS A a_1463_n395# VSS nfet_03v3 ad=0.265p pd=1.53u as=0.45p ps=2.9u w=1u l=0.28u
X5 a_1009_n395# B VDD VDD pfet_03v3 ad=0.9p pd=4.9u as=0.53p ps=2.53u w=2u l=0.28u
X6 a_1463_n395# B VSS VSS nfet_03v3 ad=0.3525p pd=1.705u as=0.265p ps=1.53u w=1u l=0.28u
X7 VDD A a_1009_n395# VDD pfet_03v3 ad=0.53p pd=2.53u as=0.9p ps=4.9u w=2u l=0.28u
X8 a_1155_n395# A a_1009_n395# VSS nfet_03v3 ad=0.265p pd=1.53u as=0.45p ps=2.9u w=1u l=0.28u
X9 Y a_1009_n395# a_1463_n395# VSS nfet_03v3 ad=0.625p pd=3.25u as=0.3525p ps=1.705u w=1u l=0.28u
C0 a_1009_n395# a_1155_n395# 0.01258f
C1 a_1009_n395# a_1463_n395# 0.48112f
C2 a_1009_n395# m1_n57_n1110# 0.01171f
C3 a_1009_n395# m2_n57_n1110# 0.00242f
C4 a_1009_n395# VDD 0.98291f
C5 a_1009_n395# A 0.10305f
C6 a_1009_n395# B 0.12848f
C7 a_1009_n395# Y 1.13443f
C8 a_1609_195# VDD 0.03167f
C9 a_1609_195# Y 0.02678f
C10 a_1155_n395# a_1463_n395# 0
C11 a_1155_n395# VDD 0
C12 a_1463_n395# m2_n57_n1110# 0
C13 a_1463_n395# VDD 0.00216f
C14 a_1463_n395# A 0.0317f
C15 a_1463_n395# B 0.03933f
C16 a_1463_n395# Y 0.08616f
C17 m1_n57_n1110# m2_n57_n1110# 0.55172f
C18 m1_n57_n1110# VDD 0.14282f
C19 m1_n57_n1110# A 0.07093f
C20 m1_n57_n1110# B 0.06992f
C21 m2_n57_n1110# VDD 0.13196f
C22 m2_n57_n1110# A 0.01915f
C23 m2_n57_n1110# B 0.01901f
C24 m2_n57_n1110# Y 0
C25 VDD A 1.14065f
C26 VDD B 0.31637f
C27 VDD Y 0.99708f
C28 A B 0.19007f
C29 A Y 0.04517f
C30 B Y 0.03429f
C31 Y VSS 1.56385f
C32 B VSS 2.3607f
C33 A VSS 1.14413f
C34 VDD VSS 8.33764f
C35 m2_n57_n1110# VSS 0.80101f ; **FLOATING
C36 m1_n57_n1110# VSS 1.26958f ; **FLOATING
C37 a_1463_n395# VSS 0.47227f
C38 a_1155_n395# VSS 0.01498f
C39 a_1609_195# VSS 0.00143f
C40 a_1009_n395# VSS 0.53309f
.ends
