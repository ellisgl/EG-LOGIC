* NGSPICE file created from NAND.ext - technology: sky130A

.subckt NAND A B Y VDD VSS
X0 Y B VDD VDD sky130_fd_pr__pfet_01v8 ad=0.285 pd=2.57 as=0.14 ps=1.28 w=1 l=0.15
X1 VSS B a_371_n201# VSS sky130_fd_pr__nfet_01v8 ad=0.18525 pd=1.87 as=0.091 ps=0.93 w=0.65 l=0.15
X2 VDD A Y VDD sky130_fd_pr__pfet_01v8 ad=0.14 pd=1.28 as=0.285 ps=2.57 w=1 l=0.15
X3 a_371_n201# A Y VSS sky130_fd_pr__nfet_01v8 ad=0.091 pd=0.93 as=0.18525 ps=1.87 w=0.65 l=0.15
C0 a_371_n201# VDD 0
C1 a_371_n201# Y 0.00891f
C2 VDD A 0.40978f
C3 VDD B 0.0838f
C4 VDD Y 0.57624f
C5 A B 0.08574f
C6 A Y 0.04397f
C7 B Y 0.04134f
C8 Y VSS 1.25473f
C9 B VSS 0.85635f
C10 A VSS 0.40447f
C11 VDD VSS 3.0692f
C12 a_371_n201# VSS 0.01051f
.ends
